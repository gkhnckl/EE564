# Ansys Electronics Desktop project, version 2017.0
materials:
  D21_50: permeability{BType=normal HUnit=A_per_meter BUnit=tesla curve (0, 0) (140, 0.4) (155, 0.45) (171, 0.5) (191, 0.55) (212, 0.6) (237, 0.65) (267, 0.7) (302, 0.75) (340, 0.8) (380, 0.85) (425, 0.9) (476, 0.95) (536, 1) (602, 1.05) (675, 1.1) (765, 1.15) (880, 1.2) (1020, 1.25) (1200, 1.3) (1450, 1.35) (1740, 1.4) (2160, 1.45) (2800, 1.5) (3850, 1.55) (5290, 1.6) (6920, 1.65) (8800, 1.7) (11000, 1.75) (13800, 1.8) (17300, 1.85) (21400, 1.9) (25000, 1.95) (30000, 2)} core_loss_type="Electrical Steel" core_loss_kh=366 core_loss_kc=0.822 core_loss_ke=0.91 mass_density=7820
  copper: permeability=0.999991 conductivity=58000000 mass_density=8933
  vacuum: permittivity=1
  D21_50_2DSF0.950: permeability{BType=normal HUnit=A_per_meter BUnit=tesla curve (0, 0) (140, 0.380009) (155, 0.42751) (171, 0.475011) (191, 0.522512) (212, 0.570013) (237, 0.617515) (267, 0.665017) (302, 0.712519) (340, 0.760021) (380, 0.807524) (425, 0.855027) (476, 0.90253) (536, 0.950034) (602, 0.997538) (675, 1.04504) (765, 1.09255) (880, 1.14006) (1020, 1.18756) (1200, 1.23508) (1450, 1.28259) (1740, 1.33011) (2160, 1.37764) (2800, 1.42518) (3850, 1.47274) (5290, 1.52033) (6920, 1.56793) (8800, 1.61555) (11000, 1.66319) (13800, 1.71087) (17300, 1.75859) (21400, 1.80634) (25000, 1.85407) (30000, 1.90188) (80000, 2.38003)} core_loss_type="Electrical Steel" core_loss_kh=385.263 core_loss_kc=0.865263 core_loss_ke=0.93364 mass_density=7429
  copper_75C: conductivity=58000000

design RMxprtDesign1 (RMxprt, Three Phase Induction Motor, model units mm)
machine:
  Machine: FrictionLoss=11W WindLoss=11W ReferenceSpeed=1450rpm NumberOfPoles=2 StrayLossFactor=0.01
  Stator: SkewWidth=0 NumberOfSlots=36 LaminationSectors=3 PressBoardThickness=0mm OuterDiameter=140mm InnerDiameter=78mm Length=250mm StackingFactor=0.95 SteelType=D21_50 SlotType=1
  Rotor: OuterDiameter=76mm InnerDiameter=32mm Length=250mm SteelType=D21_50 NumberOfSlots=28 SlotType=1 SkewWidth=1 CastRotor BottomSlotType=UserDefinedSlot StackingFactor=0.95
  Shaft: MagneticShaft
  Stator Slot: Hs0=2mm Hs1=0mm Hs2=15mm Bs0=1mm Bs1=5mm Bs2=5mm Rs=0mm ToothWidth=0mm
  Stator Winding: WindingType=Whole-Coiled WindingLayers=1 HalfTurnLength=0mm ParallelBranches=1 ConductorsPerSlot=30 CoilPitch=0 EndAdjustment=0mm BaseInnerRadius=10mm TipInnerDiameter=2mm EndClearance=1mm CoilWrap=0mm SlotLiner=1mm WedgeThickness=1mm LayerInsulation=0mm BottomInsulation=0mm LimitedFillFactor=0.75 WdgNumberofPriodicMultipler=2 WdgConstantTurns Wdgcoil_turns(30, 30, 30, 30, 30, 30, 30, 30, 30, 30, 30, 30, 30, 30, 30, 30, 30, 30) Wdgcoil_name(A, A, A, -C, -C, -C, B, B, B, -A, -A, -A, C, C, C, -B, -B, -B) Wdgcoil_go(4, 5, 6, 10, 11, 12, 16, 17, 18, 22, 23, 24, 28, 29, 30, 34, 35, 36) Wdgcoil_re(19, 20, 21, 25, 26, 27, 31, 32, 33, 1, 2, 3, 7, 8, 9, 13, 14, 15) NumberOfStrands=0 WireWrap=0mm InterturnInsulation=0mm WireDiameter=0.683mm WireWidth=0mm WireThickness=0mm Gauge=21
  Rotor Slot: Hs0=2mm Hs1=0mm Hs2=8mm Bs0=3mm Bs1=4mm Bs2=5mm Rs=0mm Hs01=2mm
  Rotor Winding: BarConductorType=copper EndLength=5mm EndRingWidth=5mm EndRingHeight=5mm EndRingConductorType=copper
setups:
  Setup1: TPIM Motor RatedOutputPower=1100W RatedVoltage=380V RatedSpeed=1450rpm OperatingTemperature=75cel LoadType=ConstPower Frequency=50Hz WindingConnection=0

design Maxwell2DDesign1 (Maxwell 2D, Transient, XY geometry, model units mm)
options: ModelDepth=250mm Multiplier=fractions
variables:
  fractions = 2
geometry:
  Band [vacuum] = user_primitive(RMxprt/Band, DiaGap=77mm, DiaYoke=32mm, Length=0mm, SegAngle=1.25deg, Fractions=1, HalfAxial=0, InfoCore=0)
  Shaft [D21_50_2DSF0.950] = user_primitive(RMxprt/Band, DiaGap=77mm, DiaYoke=32mm, Length=0mm, SegAngle=1.25deg, Fractions=1, HalfAxial=0, InfoCore=100)
  OuterRegion [vacuum] = user_primitive(RMxprt/Band, DiaGap=77mm, DiaYoke=140mm, Length=0mm, SegAngle=1.25deg, Fractions=fractions, HalfAxial=0, InfoCore=100)
  Tool = user_primitive(RMxprt/Band, DiaGap=77mm, DiaYoke=140mm, Length=0mm, SegAngle=1.25deg, Fractions=fractions, HalfAxial=0, InfoCore=1)
  Stator [D21_50_2DSF0.950] = user_primitive(RMxprt/SlotCore, DiaGap=78mm, DiaYoke=140mm, Length=0mm, Skew=0deg, Slots=36, SlotType=1, Hs0=2mm, Hs01=0mm, Hs1=2.4494897mm, Hs2=15mm, Bs0=1mm, Bs1=5mm, Bs2=5mm, Rs=2.5mm, FilletType=0, HalfSlot=0, SegAngle=15deg, LenRegion=0mm, InfoCore=0)
  Coil_0 [copper] = user_primitive(RMxprt/LapCoil, DiaGap=78mm, DiaYoke=140mm, Length=0mm, Skew=0deg, Slots=36, SlotType=1, Hs0=2mm, Hs1=2.4494897mm, Hs2=15mm, Bs0=1mm, Bs1=5mm, Bs2=5mm, Rs=2.5mm, FilletType=0, Layers=1, CoilPitch=2, EndExt=0mm, SpanExt=0mm, BendAngle=0deg, SegAngle=10deg, LenRegion=0mm, InfoCoil=2)
  Coil_1..Coil_17 [copper], Coil_18..Coil_35 = Coil_0.duplicate_around_axis(axis=Z, angle=10deg, total=36)
  Coil_0.unite(Coil_18)
  Coil_1.unite(Coil_19)
  Coil_2.unite(Coil_20)
  Coil_3.unite(Coil_21)
  Coil_4.unite(Coil_22)
  Coil_5.unite(Coil_23)
  Coil_6.unite(Coil_24)
  Coil_7.unite(Coil_25)
  Coil_8.unite(Coil_26)
  Coil_9.unite(Coil_27)
  Coil_10.unite(Coil_28)
  Coil_11.unite(Coil_29)
  Coil_12.unite(Coil_30)
  Coil_13.unite(Coil_31)
  Coil_14.unite(Coil_32)
  Coil_15.unite(Coil_33)
  Coil_16.unite(Coil_34)
  Coil_17.unite(Coil_35)
  Rotor [D21_50_2DSF0.950] = user_primitive(RMxprt/SlotCore, DiaGap=76mm, DiaYoke=32mm, Length=0mm, Skew=0deg, Slots=28, SlotType=1, Hs0=2mm, Hs01=2mm, Hs1=0mm, Hs2=8mm, Bs0=3mm, Bs1=4mm, Bs2=5mm, Rs=0mm, FilletType=0, HalfSlot=0, SegAngle=15deg, LenRegion=0mm, InfoCore=0)
  Bar [copper_75C] = user_primitive(RMxprt/SquirrelCage, DiaGap=76mm, DiaYoke=32mm, Length=0mm, Skew=0deg, Slots=28, SlotType=1, Hs0=2mm, Hs01=2mm, Hs1=0mm, Hs2=8mm, Bs0=3mm, Bs1=4mm, Bs2=5mm, Rs=0mm, FilletType=0, HalfSlot=0, BarEndExt=5mm, RingLength=5mm, RingHeight=5mm, RingDiaGap=0mm, CastRotor=1, SegAngle=15deg, LenRegion=0mm, InfoCoil=0)
  Tool_1 = Tool.copy()
  Bar.subtract(Tool_1)
  Bar_Separate1..Bar_Separate13 [copper_75C] = Bar.separate_bodies()
  InnerRegion [vacuum] = user_primitive(RMxprt/SlotCore, DiaGap=76mm, DiaYoke=32mm, Length=0mm, Skew=0deg, Slots=28, SlotType=1, Hs0=2mm, Hs01=2mm, Hs1=0mm, Hs2=8mm, Bs0=3mm, Bs1=4mm, Bs2=5mm, Rs=0mm, FilletType=0, HalfSlot=0, SegAngle=15deg, LenRegion=0mm, InfoCore=100)
  Tool_2 = Tool.copy()
  Band.subtract(Tool_2)
  Tool_3 = Tool.copy()
  InnerRegion.subtract(Tool_3)
  Tool_4 = Tool.copy()
  Shaft.subtract(Tool_4)
  Tool_5 = Tool.copy()
  Stator.subtract(Tool_5)
  Tool_6 = Tool.copy()
  Coil_0.subtract(Tool_6)
  Tool_7 = Tool.copy()
  Coil_1.subtract(Tool_7)
  Tool_8 = Tool.copy()
  Coil_2.subtract(Tool_8)
  Tool_9 = Tool.copy()
  Coil_3.subtract(Tool_9)
  Tool_10 = Tool.copy()
  Coil_4.subtract(Tool_10)
  Tool_11 = Tool.copy()
  Coil_5.subtract(Tool_11)
  Tool_12 = Tool.copy()
  Coil_6.subtract(Tool_12)
  Tool_13 = Tool.copy()
  Coil_7.subtract(Tool_13)
  Tool_14 = Tool.copy()
  Coil_8.subtract(Tool_14)
  Tool_15 = Tool.copy()
  Coil_9.subtract(Tool_15)
  Tool_16 = Tool.copy()
  Coil_10.subtract(Tool_16)
  Tool_17 = Tool.copy()
  Coil_11.subtract(Tool_17)
  Tool_18 = Tool.copy()
  Coil_12.subtract(Tool_18)
  Tool_19 = Tool.copy()
  Coil_13.subtract(Tool_19)
  Tool_20 = Tool.copy()
  Coil_14.subtract(Tool_20)
  Tool_21 = Tool.copy()
  Coil_15.subtract(Tool_21)
  Tool_22 = Tool.copy()
  Coil_16.subtract(Tool_22)
  Tool_23 = Tool.copy()
  Coil_17.subtract(Tool_23)
  Rotor.subtract(Tool)
motion:
  MotionSetup1: Band Move_Type=Rotate Coordinate_System=Global Axis=Z Is_Positive=true InitPos=0deg Angular_Velocity=2831.86rpm Objects=Band
  Moving1: Moving Objects=[Shaft, Rotor, Bar, Bar_Separate1..Bar_Separate13, InnerRegion]
boundaries and excitations:
  VectorPotential1: Vector Potential Edges=OuterRegion.edge(at (0, 70, 0)) Value=0
  Master1: Master Edges=OuterRegion.edge(at (35, 0, 0))
  Slave1: Slave Edges=OuterRegion.edge(at (-35, 0, 0)) ReverseU master=Master1 SameAsMaster=false
  PhA_0: Coil Objects=Coil_0 Conductor_number=30 Winding=PhaseA PolarityType=Positive
  PhA_1: Coil Objects=Coil_1 Conductor_number=30 Winding=PhaseA PolarityType=Positive
  PhA_2: Coil Objects=Coil_2 Conductor_number=30 Winding=PhaseA PolarityType=Positive
  PhA_3: Coil Objects=Coil_3 Conductor_number=30 Winding=PhaseA PolarityType=Positive
  PhA_4: Coil Objects=Coil_4 Conductor_number=30 Winding=PhaseA PolarityType=Positive
  PhA_5: Coil Objects=Coil_5 Conductor_number=30 Winding=PhaseA PolarityType=Positive
  PhB_6: Coil Objects=Coil_12 Conductor_number=30 Winding=PhaseB PolarityType=Positive
  PhB_7: Coil Objects=Coil_13 Conductor_number=30 Winding=PhaseB PolarityType=Positive
  PhB_8: Coil Objects=Coil_14 Conductor_number=30 Winding=PhaseB PolarityType=Positive
  PhB_9: Coil Objects=Coil_15 Conductor_number=30 Winding=PhaseB PolarityType=Positive
  PhB_10: Coil Objects=Coil_16 Conductor_number=30 Winding=PhaseB PolarityType=Positive
  PhB_11: Coil Objects=Coil_17 Conductor_number=30 Winding=PhaseB PolarityType=Positive
  PhCRe_12: Coil Objects=Coil_9 Conductor_number=30 Winding=PhaseC PolarityType=Negative
  PhCRe_13: Coil Objects=Coil_10 Conductor_number=30 Winding=PhaseC PolarityType=Negative
  PhCRe_14: Coil Objects=Coil_11 Conductor_number=30 Winding=PhaseC PolarityType=Negative
  PhCRe_15: Coil Objects=Coil_6 Conductor_number=30 Winding=PhaseC PolarityType=Negative
  PhCRe_16: Coil Objects=Coil_7 Conductor_number=30 Winding=PhaseC PolarityType=Negative
  PhCRe_17: Coil Objects=Coil_8 Conductor_number=30 Winding=PhaseC PolarityType=Negative
  EndConnection1: End Connection Objects=[Bar, Bar_Separate1..Bar_Separate13] ResistanceValue=5.27009e-006ohm InductanceValue=7.02594e-009H
  PhaseA: Winding Group Type=Voltage IsSolid=false Current=0A Resistance=4.76837ohm Inductance=0.00326542H Voltage="310.269 * sin(2*pi*50*time)" ParallelBranchesNum=1
  PhaseB: Winding Group Type=Voltage IsSolid=false Current=0A Resistance=4.76837ohm Inductance=0.00326542H Voltage="310.269 * sin(2*pi*50*time-2*pi/3)" ParallelBranchesNum=1
  PhaseC: Winding Group Type=Voltage IsSolid=false Current=0A Resistance=4.76837ohm Inductance=0.00326542H Voltage="310.269 * sin(2*pi*50*time-4*pi/3)" ParallelBranchesNum=1
  eddy effects on: Bar, Bar_Separate1..Bar_Separate13
  Y connection: PhaseA, PhaseB, PhaseC
mesh:
  Length_Coil: LengthBased RefineInside Objects=[Coil_0..Coil_17] MaxLength=2.5mm
  Length_Bar: LengthBased RefineInside Objects=[Bar, Bar_Separate1..Bar_Separate13] MaxLength=2mm
  SurfApprox_Bar: SurfApproxBased Objects=[Bar, Bar_Separate1..Bar_Separate13] CurvedSurfaceApproxChoice=ManualSettings SurfDev=0.038mm NormalDev=15deg
  SurfApprox_Main: SurfApproxBased Objects=[Stator, Rotor, Band, OuterRegion, InnerRegion, Shaft] CurvedSurfaceApproxChoice=ManualSettings SurfDev=0.07mm NormalDev=15deg
  Length_Main: LengthBased RefineInside Objects=[Stator, Rotor, Band, OuterRegion, InnerRegion, Shaft] MaxLength=6.4mm
  initial mesh: MeshMethod=AnsoftTAU
setups:
  Setup1: Transient NonlinearSolverResidual=0.0001 StopTime=200ms TimeStep=1ms FastReachSteadyState FrequencyOfAddedVoltageSource=50Hz SweepSetupType=LinearStep StartValue=0 StopValue=10ms StepSize=1ms InitialTimeStep=0.002s MinTimeStep=0.001s MaxTimeStep=0.003s TimeStepErrTolerance=0.0001
field plots:
  Flux_Lines1: A over Band, Shaft, OuterRegion, Stator, Coil_0..Coil_17, Rotor, Bar, Bar_Separate1..Bar_Separate13, InnerRegion on Setup1 : Transient at Time=0.001s
reports:
  Torque: Moving1.Torque vs Time on Setup1 : Transient
  Currents: Current(PhaseA), Current(PhaseB), Current(PhaseC) vs Time on Setup1 : Transient
  Induced Voltages: InducedVoltage(PhaseA), InducedVoltage(PhaseB), InducedVoltage(PhaseC) vs Time on Setup1 : Transient
  Flux Linkages: FluxLinkage(PhaseA), FluxLinkage(PhaseB), FluxLinkage(PhaseC) vs Time on Setup1 : Transient
  Voltages: InputVoltage(PhaseA), InputVoltage(PhaseB), InputVoltage(PhaseC) vs Time on Setup1 : Transient
  Powers: InputVoltage(PhaseA)*Current(PhaseA) + InputVoltage(PhaseB)*Current(PhaseB) + InputVoltage(PhaseC)*Current(PhaseC), Moving1.Speed*Moving1.Torque vs Time on Setup1 : Transient
  XY Plot 1: FluxLinkage(PhaseA), FluxLinkage(PhaseB), FluxLinkage(PhaseC), InducedVoltage(PhaseA), InducedVoltage(PhaseB), InducedVoltage(PhaseC) vs Time on Setup1 : Transient
  XY Plot 2: Moving1.Speed vs Time on Setup1 : Transient
