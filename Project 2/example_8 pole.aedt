# Ansys Electronics Desktop project, version 2017.0
materials:
  M19_24G: permeability{BType=normal HUnit=A_per_meter BUnit=tesla curve (0, 0) (22.28, 0.05) (25.46, 0.1) (31.83, 0.15) (47.74, 0.36) (63.66, 0.54) (79.57, 0.65) (159.15, 0.99) (318.3, 1.2) (477.46, 1.28) (636.61, 1.33) (795.77, 1.36) (1591.5, 1.44) (3183, 1.52) (4774.6, 1.58) (6366.1, 1.63) (7957.7, 1.67) (15915, 1.8) (31830, 1.9) (111407, 2) (190984, 2.1) (350138, 2.3) (509292, 2.5)} conductivity=1960000 core_loss_type="Electrical Steel" core_loss_kh=164.2 core_loss_kc=1.3 core_loss_ke=1.72 mass_density=7650
  cast_aluminum_75C: permeability=1.000021 conductivity=23000000

design yzd132-8 (RMxprt, Three Phase Induction Motor, model units mm)
machine:
  Machine: FrictionLoss=37W WindLoss=0W ReferenceSpeed=700rpm NumberOfPoles=8 StrayLossFactor=0.01
  Stator: SkewWidth=0 NumberOfSlots=48 LaminationSectors=0 PressBoardThickness=0mm OuterDiameter=210mm InnerDiameter=148mm Length=250mm StackingFactor=0.92 SteelType=M19_24G SlotType=2
  Rotor: OuterDiameter=147.3mm InnerDiameter=48mm Length=250mm SteelType=M19_24G NumberOfSlots=44 SlotType=2 SkewWidth=0 BottomSlotType=2 StackingFactor=0.92
  Shaft:
  Stator Slot: Hs0=0.8mm Hs1=1.05mm Hs2=12.9mm Bs0=2.8mm Bs1=4.9mm Bs2=6.7mm Rs=0mm ToothWidth=0mm
  Stator Winding: WindingType=Editor WindingLayers=1 ParallelBranches=1 ConductorsPerSlot=30 CoilPitch=7 EndAdjustment=0mm BaseInnerRadius=0mm TipInnerDiameter=0mm EndClearance=0mm CoilWrap=0mm SlotLiner=0.3mm WedgeThickness=0mm LayerInsulation=0mm BottomInsulation=0mm LimitedFillFactor=0.75 WdgNumberofPriodicMultipler=8 WdgConstantTurns Wdgcoil_turns(30, 30, 30, 30, 30, 30, 30, 30, 30, 30, 30, 30, 30, 30, 30, 30, 30, 30, 30, 30, 30, 30, 30, 30) Wdgcoil_name(A, -C, B, -A, C, -B, A, -C, B, -A, C, -B, A, -C, B, -A, C, -B, A, -C, B, -A, C, -B) Wdgcoil_go(2, 4, 6, 8, 10, 12, 14, 16, 18, 20, 22, 24, 26, 28, 30, 32, 34, 36, 38, 40, 42, 44, 46, 48) Wdgcoil_re(7, 9, 11, 13, 15, 17, 19, 21, 23, 25, 27, 29, 31, 33, 35, 37, 39, 41, 43, 45, 47, 1, 3, 5) NumberOfStrands=2 WireWrap=0.09mm InterturnInsulation=0mm WireDiameter=0.93mm WireWidth=0mm WireThickness=0mm Gauge=USER
  Rotor Slot: Hs0=0.5mm Hs1=1.2mm Hs2=12mm Bs0=1mm Bs1=5.2mm Bs2=3.5mm Rs=0mm Hs01=0mm
  Rotor Winding: BarConductorType=cast_aluminum_75C EndLength=0mm EndRingWidth=20mm EndRingHeight=10mm EndRingConductorType=cast_aluminum_75C
  Rotor Vent: VentDucts=0 DuctWidth=0mm MagneticSpacerWidth=0mm DuctPitch=0mm HolesperRow=0 InnerHoleDiameter=0mm OuterHoleDiameter=0mm InnerHoleLocation=0mm OuterHoleLocation=0mm
setups:
  Setup1: TPIM Motor RatedOutputPower=3700W RatedVoltage=380V RatedSpeed=700rpm OperatingTemperature=75cel LoadType=ConstPower Frequency=50Hz WindingConnection=1
