# Ansys Electronics Desktop project, version 2017.0
materials:
  D21_50: permeability{BType=normal HUnit=A_per_meter BUnit=tesla curve (0, 0) (140, 0.4) (155, 0.45) (171, 0.5) (191, 0.55) (212, 0.6) (237, 0.65) (267, 0.7) (302, 0.75) (340, 0.8) (380, 0.85) (425, 0.9) (476, 0.95) (536, 1) (602, 1.05) (675, 1.1) (765, 1.15) (880, 1.2) (1020, 1.25) (1200, 1.3) (1450, 1.35) (1740, 1.4) (2160, 1.45) (2800, 1.5) (3850, 1.55) (5290, 1.6) (6920, 1.65) (8800, 1.7) (11000, 1.75) (13800, 1.8) (17300, 1.85) (21400, 1.9) (25000, 1.95) (30000, 2)} core_loss_type="Electrical Steel" core_loss_kh=366 core_loss_kc=0.822 core_loss_ke=0.91 mass_density=7820
  copper: permeability=0.999991 conductivity=58000000 mass_density=8933
  vacuum: permittivity=1
  D21_50_2DSF0.950: permeability{BType=normal HUnit=A_per_meter BUnit=tesla curve (0, 0) (140, 0.380009) (155, 0.42751) (171, 0.475011) (191, 0.522512) (212, 0.570013) (237, 0.617515) (267, 0.665017) (302, 0.712519) (340, 0.760021) (380, 0.807524) (425, 0.855027) (476, 0.90253) (536, 0.950034) (602, 0.997538) (675, 1.04504) (765, 1.09255) (880, 1.14006) (1020, 1.18756) (1200, 1.23508) (1450, 1.28259) (1740, 1.33011) (2160, 1.37764) (2800, 1.42518) (3850, 1.47274) (5290, 1.52033) (6920, 1.56793) (8800, 1.61555) (11000, 1.66319) (13800, 1.71087) (17300, 1.75859) (21400, 1.80634) (25000, 1.85407) (30000, 1.90188) (80000, 2.38003)} core_loss_type="Electrical Steel" core_loss_kh=385.263 core_loss_kc=0.865263 core_loss_ke=0.93364 mass_density=7429
  copper_75C: conductivity=58000000
  D21_50_3DSF0.950: permeability{BType=normal HUnit=A_per_meter BUnit=tesla curve (0, 0) (140, 0.4) (155, 0.45) (171, 0.5) (191, 0.55) (212, 0.6) (237, 0.65) (267, 0.7) (302, 0.75) (340, 0.8) (380, 0.85) (425, 0.9) (476, 0.95) (536, 1) (602, 1.05) (675, 1.1) (765, 1.15) (880, 1.2) (1020, 1.25) (1200, 1.3) (1450, 1.35) (1740, 1.4) (2160, 1.45) (2800, 1.5) (3850, 1.55) (5290, 1.6) (6920, 1.65) (8800, 1.7) (11000, 1.75) (13800, 1.8) (17300, 1.85) (21400, 1.9) (25000, 1.95) (30000, 2) (80000, 2.5)} core_loss_type="Electrical Steel" core_loss_kh=366 core_loss_kc=0.822 core_loss_ke=0.91 mass_density=7820 stacking_type=Lamination stacking_factor=0.95 stacking_direction=V(3)
  steel_1010: permittivity=1 permeability{BType=normal HUnit=A_per_meter BUnit=tesla curve (0, 0) (238.7, 0.2003) (318.3, 0.3204) (358.1, 0.40045) (437.7, 0.50055) (477.5, 0.5606) (636.6, 0.7908) (795.8, 0.931) (1114.1, 1.1014) (1273.2, 1.2016) (1591.5, 1.302) (2228.2, 1.4028) (3183.1, 1.524) (4774.6, 1.626) (6366.2, 1.698) (7957.7, 1.73) (15915.5, 1.87) (31831, 1.99) (47746.5, 2.04) (63662, 2.07) (79577.5, 2.095) (159155, 2.2) (318310, 2.4)} conductivity=2000000 lande_g_factor=2 mass_density=7872
  steel_1010_2DSF0.950: permeability{BType=normal HUnit=A_per_meter BUnit=tesla curve (0, 0) (238.7, 0.1903) (318.3, 0.3044) (358.1, 0.38045) (437.7, 0.47555) (477.5, 0.5326) (636.6, 0.7513) (795.8, 0.8845) (1114.1, 1.0464) (1273.2, 1.1416) (1591.5, 1.237) (2228.2, 1.3328) (3183.1, 1.448) (4774.6, 1.545) (6366.2, 1.6135) (7957.7, 1.644) (15915.5, 1.7775) (31831, 1.8925) (47746.5, 1.941) (63662, 1.9705) (79577.5, 1.99525) (159155, 2.1) (318310, 2.3) (1909860, 4.3)} conductivity=2000000 mass_density=7478.4
  aluminum: permeability=1.000021 conductivity=38000000 mass_density=2689
  aluminum_75C: conductivity=38000000
  JFE_Steel_20JNEH1200: core_loss_curve{50Hz (0, 0) (0.5, 0.28) (0.55, 0.34) (0.6, 0.39) (0.65, 0.45) (0.7, 0.5) (0.75, 0.56) (0.8, 0.62) (0.85, 0.68) (0.9, 0.74) (0.95, 0.81) (1, 0.88) (1.05, 0.97) (1.1, 1.05) (1.15, 1.15) (1.2, 1.25) (1.25, 1.37) (1.3, 1.5) (1.35, 1.64) (1.4, 1.79) (1.45, 1.96) (1.5, 2.14) (1.55, 2.32) (1.6, 2.51) (1.65, 2.71) (1.7, 2.9)} core_loss_curve{60Hz (0, 0) (0.5, 0.34) (0.55, 0.39) (0.6, 0.45) (0.65, 0.52) (0.7, 0.59) (0.75, 0.67) (0.8, 0.75) (0.85, 0.84) (0.9, 0.93) (0.95, 1.03) (1, 1.13) (1.05, 1.24) (1.1, 1.35) (1.15, 1.47) (1.2, 1.6) (1.25, 1.73) (1.3, 1.88) (1.35, 2.04) (1.4, 2.21) (1.45, 2.39) (1.5, 2.58) (1.55, 2.79) (1.6, 3) (1.65, 3.22) (1.7, 3.45)} core_loss_curve{100Hz (0, 0) (0.066, 0.01) (0.1, 0.028) (0.2, 0.127) (0.3, 0.274) (0.4, 0.446) (0.5, 0.639) (0.6, 0.856) (0.7, 1.09) (0.8, 1.35) (0.9, 1.62) (1, 1.92) (1.1, 2.29) (1.2, 2.71) (1.3, 3.17) (1.4, 3.72) (1.5, 4.3)} core_loss_curve{200Hz (0, 0) (0.046, 0.01) (0.1, 0.0611) (0.2, 0.269) (0.3, 0.577) (0.4, 0.977) (0.5, 1.43) (0.6, 1.92) (0.7, 2.47) (0.8, 3.08) (0.9, 3.77) (1, 4.53) (1.1, 5.4) (1.2, 6.35) (1.3, 7.4) (1.4, 8.63) (1.5, 10)} core_loss_curve{400Hz (0, 0) (0.032, 0.01) (0.1, 0.14) (0.2, 0.617) (0.3, 1.4) (0.4, 2.37) (0.5, 3.44) (0.6, 4.63) (0.7, 5.93) (0.8, 7.37) (0.9, 9.05) (1, 10.9) (1.1, 13.1) (1.2, 15.6) (1.3, 18.4) (1.4, 21.6) (1.5, 25.1)} core_loss_curve{1kHz (0, 0) (0.0153, 0.01) (0.1, 0.557) (0.2, 2.25) (0.3, 4.91) (0.4, 8.36) (0.5, 12.5) (0.6, 17.4) (0.7, 22.5) (0.8, 28.2) (0.9, 34.8) (1, 42.1) (1.1, 50.7) (1.2, 60.2) (1.3, 70.9) (1.4, 83.5) (1.5, 98.4)} core_loss_curve{2kHz (0, 0) (0.01, 0.014) (0.1, 1.57) (0.2, 6.05) (0.3, 13.3) (0.4, 22.5) (0.5, 33.2) (0.6, 45.6) (0.7, 59.6) (0.8, 74.9) (0.9, 92.1) (0.94, 100)} core_loss_curve{5kHz (0, 0) (0.01, 0.077) (0.1, 6.8) (0.15, 14.7) (0.2, 24.4) (0.3, 51) (0.4, 86.9) (0.43, 100)} core_loss_curve{10kHz (0, 0) (0.01, 0.255) (0.05, 6.7) (0.1, 20.9) (0.15, 45.2) (0.2, 77.3) (0.23, 100)} permeability{BType=normal HUnit=A_per_meter BUnit=tesla curve (0, 0) (10, 0.01) (19.6, 0.05) (26.6, 0.1) (30.9, 0.15) (33.9, 0.2) (36.4, 0.25) (38.8, 0.3) (41.4, 0.3501) (44, 0.4001) (46.6, 0.45) (49.3, 0.5001) (52, 0.5501) (54.9, 0.6001) (57.9, 0.6501) (61.2, 0.7001) (65, 0.7501) (69.1, 0.8001) (73.9, 0.8501) (79.2, 0.9001) (85.2, 0.9501) (92.3, 1.0001) (101, 1.0501) (112, 1.1001) (127, 1.1502) (146, 1.2002) (172, 1.2502) (209, 1.3003) (263, 1.3503) (357, 1.4004) (554, 1.4507) (1060, 1.5013) (1900, 1.5524) (2910, 1.6037) (4080, 1.6551) (5000, 1.6854) (5670, 1.7071) (7900, 1.7599) (10000, 1.7944) (11200, 1.8141) (16000, 1.8701) (24100, 1.9303) (42300, 2.0032) (80000, 2.0805)} conductivity=1818182 core_loss_type="Electrical Steel" core_loss_kh=173.2958 core_loss_kc=0.085956172 core_loss_ke=2.0678793 mass_density=7650

design RMxprtDesign1 (RMxprt, Three Phase Induction Motor, model units mm)
machine:
  Machine: FrictionLoss=0W WindLoss=0W ReferenceSpeed=1485rpm NumberOfPoles=4 StrayLossFactor=0.01
  Stator: SkewWidth=0 NumberOfSlots=36 LaminationSectors=1 PressBoardThickness=0mm OuterDiameter=200mm InnerDiameter=135mm Length=135mm StackingFactor=0.95 SteelType=JFE_Steel_20JNEH1200 SlotType=4
  Rotor: OuterDiameter=133.4mm InnerDiameter=61.4mm Length=135mm SteelType=steel_1010 NumberOfSlots=34 SlotType=4 SkewWidth=1 CastRotor BottomSlotType=3 StackingFactor=0.95
  Shaft:
  Stator Slot: Hs0=0.59mm Hs1=0mm Hs2=17.61mm Bs0=2.5mm Bs1=5.35mm Bs2=7.95mm Rs=1.2mm ToothWidth=0mm
  Stator Winding: WindingType=Half-Coiled WindingLayers=1 HalfTurnLength=0mm ParallelBranches=1 ConductorsPerSlot=34 CoilPitch=0 EndAdjustment=0mm BaseInnerRadius=1mm TipInnerDiameter=1mm EndClearance=0.001mm CoilWrap=0mm SlotLiner=0mm WedgeThickness=0mm LayerInsulation=0mm BottomInsulation=0mm LimitedFillFactor=0.75 WdgNumberofPriodicMultipler=2 WdgConstantTurns Wdgcoil_turns(30, 30, 30, 30, 30, 30, 30, 30, 30, 30, 30, 30, 30, 30, 30, 30, 30, 30) Wdgcoil_name(A, A, A, -C, -C, -C, B, B, B, -A, -A, -A, C, C, C, -B, -B, -B) Wdgcoil_go(4, 5, 6, 10, 11, 12, 16, 17, 18, 22, 23, 24, 28, 29, 30, 34, 35, 36) Wdgcoil_re(19, 20, 21, 25, 26, 27, 31, 32, 33, 1, 2, 3, 7, 8, 9, 13, 14, 15) NumberOfStrands=1 WireWrap=0mm InterturnInsulation=0mm WireDiameter=1.725mm WireWidth=0mm WireThickness=0mm Gauge=13
  Rotor Slot: Hs0=0.7mm Hs1=0mm Hs2=19mm Bs0=1mm Bs1=4.7mm Bs2=2.03mm Rs=0.89mm Hs01=0mm
  Rotor Winding: BarConductorType=aluminum EndLength=20mm EndRingWidth=20mm EndRingHeight=20mm EndRingConductorType=aluminum
setups:
  Setup1: TPIM Motor RatedOutputPower=4000W RatedVoltage=380V RatedSpeed=1450rpm OperatingTemperature=75cel LoadType=ConstPower Frequency=50Hz WindingConnection=0

design Maxwell2DDesign1 (Maxwell 2D, Transient, XY geometry, model units mm)
options: ModelDepth=135mm Multiplier=fractions
variables:
  fractions = 2
geometry:
  Band [vacuum] = user_primitive(RMxprt/Band, DiaGap=134.2mm, DiaYoke=61.4mm, Length=0mm, SegAngle=1.25deg, Fractions=1, HalfAxial=0, InfoCore=0)
  Shaft [vacuum] = user_primitive(RMxprt/Band, DiaGap=134.2mm, DiaYoke=61.4mm, Length=0mm, SegAngle=1.25deg, Fractions=1, HalfAxial=0, InfoCore=100)
  OuterRegion [vacuum] = user_primitive(RMxprt/Band, DiaGap=134.2mm, DiaYoke=200mm, Length=0mm, SegAngle=1.25deg, Fractions=fractions, HalfAxial=0, InfoCore=100)
  Tool = user_primitive(RMxprt/Band, DiaGap=134.2mm, DiaYoke=200mm, Length=0mm, SegAngle=1.25deg, Fractions=fractions, HalfAxial=0, InfoCore=1)
  Stator [steel_1010_2DSF0.950] = user_primitive(RMxprt/SlotCore, DiaGap=135mm, DiaYoke=200mm, Length=0mm, Skew=0deg, Slots=36, SlotType=4, Hs0=0.59mm, Hs01=0mm, Hs1=0mm, Hs2=17.61mm, Bs0=2.5mm, Bs1=5.35mm, Bs2=7.95mm, Rs=1.2mm, FilletType=0, HalfSlot=0, SegAngle=15deg, LenRegion=0mm, InfoCore=0)
  Coil_0 [copper] = user_primitive(RMxprt/LapCoil, DiaGap=135mm, DiaYoke=200mm, Length=0mm, Skew=0deg, Slots=36, SlotType=4, Hs0=0.59mm, Hs1=0mm, Hs2=17.61mm, Bs0=2.5mm, Bs1=5.35mm, Bs2=7.95mm, Rs=1.2mm, FilletType=0, Layers=1, CoilPitch=2, EndExt=0mm, SpanExt=0mm, BendAngle=0deg, SegAngle=10deg, LenRegion=0mm, InfoCoil=2)
  Coil_1..Coil_17 [copper], Coil_18..Coil_35 = Coil_0.duplicate_around_axis(axis=Z, angle=10deg, total=36)
  Coil_0.unite(Coil_18)
  Coil_1.unite(Coil_19)
  Coil_2.unite(Coil_20)
  Coil_3.unite(Coil_21)
  Coil_4.unite(Coil_22)
  Coil_5.unite(Coil_23)
  Coil_6.unite(Coil_24)
  Coil_7.unite(Coil_25)
  Coil_8.unite(Coil_26)
  Coil_9.unite(Coil_27)
  Coil_10.unite(Coil_28)
  Coil_11.unite(Coil_29)
  Coil_12.unite(Coil_30)
  Coil_13.unite(Coil_31)
  Coil_14.unite(Coil_32)
  Coil_15.unite(Coil_33)
  Coil_16.unite(Coil_34)
  Coil_17.unite(Coil_35)
  Rotor [steel_1010_2DSF0.950] = user_primitive(RMxprt/SlotCore, DiaGap=133.4mm, DiaYoke=61.4mm, Length=0mm, Skew=0deg, Slots=34, SlotType=4, Hs0=0.7mm, Hs01=0mm, Hs1=0mm, Hs2=19mm, Bs0=1mm, Bs1=4.7mm, Bs2=2.03mm, Rs=0.89mm, FilletType=0, HalfSlot=0, SegAngle=15deg, LenRegion=0mm, InfoCore=0)
  Bar [aluminum_75C] = user_primitive(RMxprt/SquirrelCage, DiaGap=133.4mm, DiaYoke=61.4mm, Length=0mm, Skew=0deg, Slots=34, SlotType=4, Hs0=0.7mm, Hs01=0mm, Hs1=0mm, Hs2=19mm, Bs0=1mm, Bs1=4.7mm, Bs2=2.03mm, Rs=0.89mm, FilletType=0, HalfSlot=0, BarEndExt=20mm, RingLength=20mm, RingHeight=20mm, RingDiaGap=0mm, CastRotor=1, SegAngle=15deg, LenRegion=0mm, InfoCoil=0)
  Tool_1 = Tool.copy()
  Bar.subtract(Tool_1)
  Bar_Separate1..Bar_Separate16 [aluminum_75C] = Bar.separate_bodies()
  InnerRegion [vacuum] = user_primitive(RMxprt/SlotCore, DiaGap=133.4mm, DiaYoke=61.4mm, Length=0mm, Skew=0deg, Slots=34, SlotType=4, Hs0=0.7mm, Hs01=0mm, Hs1=0mm, Hs2=19mm, Bs0=1mm, Bs1=4.7mm, Bs2=2.03mm, Rs=0.89mm, FilletType=0, HalfSlot=0, SegAngle=15deg, LenRegion=0mm, InfoCore=100)
  Tool_2 = Tool.copy()
  Band.subtract(Tool_2)
  Tool_3 = Tool.copy()
  InnerRegion.subtract(Tool_3)
  Tool_4 = Tool.copy()
  Shaft.subtract(Tool_4)
  Tool_5 = Tool.copy()
  Stator.subtract(Tool_5)
  Tool_6 = Tool.copy()
  Coil_0.subtract(Tool_6)
  Tool_7 = Tool.copy()
  Coil_1.subtract(Tool_7)
  Tool_8 = Tool.copy()
  Coil_2.subtract(Tool_8)
  Tool_9 = Tool.copy()
  Coil_3.subtract(Tool_9)
  Tool_10 = Tool.copy()
  Coil_4.subtract(Tool_10)
  Tool_11 = Tool.copy()
  Coil_5.subtract(Tool_11)
  Tool_12 = Tool.copy()
  Coil_6.subtract(Tool_12)
  Tool_13 = Tool.copy()
  Coil_7.subtract(Tool_13)
  Tool_14 = Tool.copy()
  Coil_8.subtract(Tool_14)
  Tool_15 = Tool.copy()
  Coil_9.subtract(Tool_15)
  Tool_16 = Tool.copy()
  Coil_10.subtract(Tool_16)
  Tool_17 = Tool.copy()
  Coil_11.subtract(Tool_17)
  Tool_18 = Tool.copy()
  Coil_12.subtract(Tool_18)
  Tool_19 = Tool.copy()
  Coil_13.subtract(Tool_19)
  Tool_20 = Tool.copy()
  Coil_14.subtract(Tool_20)
  Tool_21 = Tool.copy()
  Coil_15.subtract(Tool_21)
  Tool_22 = Tool.copy()
  Coil_16.subtract(Tool_22)
  Tool_23 = Tool.copy()
  Coil_17.subtract(Tool_23)
  Rotor.subtract(Tool)
motion:
  MotionSetup1: Band Move_Type=Rotate Coordinate_System=Global Axis=Z Is_Positive=true InitPos=0deg Angular_Velocity=1442.84rpm Objects=Band
  Moving1: Moving Objects=[Shaft, Rotor, Bar, Bar_Separate1..Bar_Separate16, InnerRegion]
boundaries and excitations:
  VectorPotential1: Vector Potential Edges=OuterRegion.edge(at (0, 100, 0)) Value=0
  Master1: Master Edges=OuterRegion.edge(at (50, 0, 0))
  Slave1: Slave Edges=OuterRegion.edge(at (-50, 0, 0)) ReverseU master=Master1 SameAsMaster=true
  PhA_0: Coil Objects=Coil_0 Conductor_number=34 Winding=PhaseA PolarityType=Positive
  PhARe_0: Coil Objects=Coil_9 Conductor_number=34 Winding=PhaseA PolarityType=Negative
  PhA_1: Coil Objects=Coil_1 Conductor_number=34 Winding=PhaseA PolarityType=Positive
  PhARe_1: Coil Objects=Coil_10 Conductor_number=34 Winding=PhaseA PolarityType=Negative
  PhA_2: Coil Objects=Coil_2 Conductor_number=34 Winding=PhaseA PolarityType=Positive
  PhARe_2: Coil Objects=Coil_11 Conductor_number=34 Winding=PhaseA PolarityType=Negative
  PhB_3: Coil Objects=Coil_6 Conductor_number=34 Winding=PhaseB PolarityType=Positive
  PhBRe_3: Coil Objects=Coil_15 Conductor_number=34 Winding=PhaseB PolarityType=Negative
  PhB_4: Coil Objects=Coil_7 Conductor_number=34 Winding=PhaseB PolarityType=Positive
  PhBRe_4: Coil Objects=Coil_16 Conductor_number=34 Winding=PhaseB PolarityType=Negative
  PhB_5: Coil Objects=Coil_8 Conductor_number=34 Winding=PhaseB PolarityType=Positive
  PhBRe_5: Coil Objects=Coil_17 Conductor_number=34 Winding=PhaseB PolarityType=Negative
  PhC_6: Coil Objects=Coil_12 Conductor_number=34 Winding=PhaseC PolarityType=Positive
  PhC_7: Coil Objects=Coil_13 Conductor_number=34 Winding=PhaseC PolarityType=Positive
  PhC_8: Coil Objects=Coil_14 Conductor_number=34 Winding=PhaseC PolarityType=Positive
  PhCRe_15: Coil Objects=Coil_3 Conductor_number=34 Winding=PhaseC PolarityType=Negative
  PhCRe_16: Coil Objects=Coil_4 Conductor_number=34 Winding=PhaseC PolarityType=Negative
  PhCRe_17: Coil Objects=Coil_5 Conductor_number=34 Winding=PhaseC PolarityType=Negative
  EndConnection1: End Connection Objects=[Bar, Bar_Separate1..Bar_Separate16] ResistanceValue=1.77688e-006ohm InductanceValue=9.23475e-009H
  PhaseA: Winding Group Type=Voltage IsSolid=false Current=0A Resistance=1.10364ohm Inductance=0.00252817H Voltage="310.269 * sin(2*pi*50*time)" ParallelBranchesNum=1
  PhaseB: Winding Group Type=Voltage IsSolid=false Current=0A Resistance=1.10364ohm Inductance=0.00252817H Voltage="310.269 * sin(2*pi*50*time-2*pi/3)" ParallelBranchesNum=1
  PhaseC: Winding Group Type=Voltage IsSolid=false Current=0A Resistance=1.10364ohm Inductance=0.00252817H Voltage="310.269 * sin(2*pi*50*time-4*pi/3)" ParallelBranchesNum=1
  Y connection: PhaseA, PhaseB, PhaseC
mesh:
  Length_Coil: LengthBased RefineInside Objects=[Coil_0..Coil_17] MaxLength=3.325mm
  Length_Bar: LengthBased RefineInside Objects=[Bar, Bar_Separate1..Bar_Separate16] MaxLength=1.015mm
  SurfApprox_Bar: SurfApproxBased Objects=[Bar, Bar_Separate1..Bar_Separate16] CurvedSurfaceApproxChoice=ManualSettings SurfDev=0.0667mm NormalDev=15deg
  SurfApprox_Main: SurfApproxBased Objects=[Stator, Rotor, Band, OuterRegion, InnerRegion, Shaft] CurvedSurfaceApproxChoice=ManualSettings SurfDev=0.1mm NormalDev=15deg
  Length_Main: LengthBased RefineInside Objects=[Stator, Rotor, Band, OuterRegion, InnerRegion, Shaft] MaxLength=6.66mm
  initial mesh: MeshMethod=AnsoftTAU
setups:
  Setup1: Transient NonlinearSolverResidual=0.0001 StopTime=0.04s TimeStep=0.0002s FastReachSteadyState FrequencyOfAddedVoltageSource=50Hz InitialTimeStep=0.002s MinTimeStep=0.001s MaxTimeStep=0.003s TimeStepErrTolerance=0.0001
reports:
  Torque: Moving1.Torque vs Time on Setup1 : Transient
  Currents: Current(PhaseA), Current(PhaseB), Current(PhaseC) vs Time on Setup1 : Transient
  Induced Voltages: InducedVoltage(PhaseA), InducedVoltage(PhaseB), InducedVoltage(PhaseC) vs Time on Setup1 : Transient
  Flux Linkages: FluxLinkage(PhaseA), FluxLinkage(PhaseB), FluxLinkage(PhaseC) vs Time on Setup1 : Transient
  Voltages: InputVoltage(PhaseA), InputVoltage(PhaseB), InputVoltage(PhaseC) vs Time on Setup1 : Transient
  Powers: InputVoltage(PhaseA)*Current(PhaseA) + InputVoltage(PhaseB)*Current(PhaseB) + InputVoltage(PhaseC)*Current(PhaseC), Moving1.Speed*Moving1.Torque vs Time on Setup1 : Transient
