# Ansys Electronics Desktop project, version 2017.0
materials:
  D21_50: permeability{BType=normal HUnit=A_per_meter BUnit=tesla curve (0, 0) (140, 0.4) (155, 0.45) (171, 0.5) (191, 0.55) (212, 0.6) (237, 0.65) (267, 0.7) (302, 0.75) (340, 0.8) (380, 0.85) (425, 0.9) (476, 0.95) (536, 1) (602, 1.05) (675, 1.1) (765, 1.15) (880, 1.2) (1020, 1.25) (1200, 1.3) (1450, 1.35) (1740, 1.4) (2160, 1.45) (2800, 1.5) (3850, 1.55) (5290, 1.6) (6920, 1.65) (8800, 1.7) (11000, 1.75) (13800, 1.8) (17300, 1.85) (21400, 1.9) (25000, 1.95) (30000, 2)} core_loss_type="Electrical Steel" core_loss_kh=366 core_loss_kc=0.822 core_loss_ke=0.91 mass_density=7820
  copper: permeability=0.999991 conductivity=58000000 mass_density=8933
  vacuum: permittivity=1
  D21_50_2DSF0.950: permeability{BType=normal HUnit=A_per_meter BUnit=tesla curve (0, 0) (140, 0.380009) (155, 0.42751) (171, 0.475011) (191, 0.522512) (212, 0.570013) (237, 0.617515) (267, 0.665017) (302, 0.712519) (340, 0.760021) (380, 0.807524) (425, 0.855027) (476, 0.90253) (536, 0.950034) (602, 0.997538) (675, 1.04504) (765, 1.09255) (880, 1.14006) (1020, 1.18756) (1200, 1.23508) (1450, 1.28259) (1740, 1.33011) (2160, 1.37764) (2800, 1.42518) (3850, 1.47274) (5290, 1.52033) (6920, 1.56793) (8800, 1.61555) (11000, 1.66319) (13800, 1.71087) (17300, 1.75859) (21400, 1.80634) (25000, 1.85407) (30000, 1.90188) (80000, 2.38003)} core_loss_type="Electrical Steel" core_loss_kh=385.263 core_loss_kc=0.865263 core_loss_ke=0.93364 mass_density=7429
  copper_75C: conductivity=58000000
  D21_50_3DSF0.950: permeability{BType=normal HUnit=A_per_meter BUnit=tesla curve (0, 0) (140, 0.4) (155, 0.45) (171, 0.5) (191, 0.55) (212, 0.6) (237, 0.65) (267, 0.7) (302, 0.75) (340, 0.8) (380, 0.85) (425, 0.9) (476, 0.95) (536, 1) (602, 1.05) (675, 1.1) (765, 1.15) (880, 1.2) (1020, 1.25) (1200, 1.3) (1450, 1.35) (1740, 1.4) (2160, 1.45) (2800, 1.5) (3850, 1.55) (5290, 1.6) (6920, 1.65) (8800, 1.7) (11000, 1.75) (13800, 1.8) (17300, 1.85) (21400, 1.9) (25000, 1.95) (30000, 2) (80000, 2.5)} core_loss_type="Electrical Steel" core_loss_kh=366 core_loss_kc=0.822 core_loss_ke=0.91 mass_density=7820 stacking_type=Lamination stacking_factor=0.95 stacking_direction=V(3)
  steel_1010: permittivity=1 permeability{BType=normal HUnit=A_per_meter BUnit=tesla curve (0, 0) (238.7, 0.2003) (318.3, 0.3204) (358.1, 0.40045) (437.7, 0.50055) (477.5, 0.5606) (636.6, 0.7908) (795.8, 0.931) (1114.1, 1.1014) (1273.2, 1.2016) (1591.5, 1.302) (2228.2, 1.4028) (3183.1, 1.524) (4774.6, 1.626) (6366.2, 1.698) (7957.7, 1.73) (15915.5, 1.87) (31831, 1.99) (47746.5, 2.04) (63662, 2.07) (79577.5, 2.095) (159155, 2.2) (318310, 2.4)} conductivity=2000000 lande_g_factor=2 mass_density=7872
  steel_1010_2DSF0.950: permeability{BType=normal HUnit=A_per_meter BUnit=tesla curve (0, 0) (238.7, 0.1903) (318.3, 0.3044) (358.1, 0.38045) (437.7, 0.47555) (477.5, 0.5326) (636.6, 0.7513) (795.8, 0.8845) (1114.1, 1.0464) (1273.2, 1.1416) (1591.5, 1.237) (2228.2, 1.3328) (3183.1, 1.448) (4774.6, 1.545) (6366.2, 1.6135) (7957.7, 1.644) (15915.5, 1.7775) (31831, 1.8925) (47746.5, 1.941) (63662, 1.9705) (79577.5, 1.99525) (159155, 2.1) (318310, 2.3) (1909860, 4.3)} conductivity=2000000 mass_density=7478.4
  aluminum: permeability=1.000021 conductivity=38000000 mass_density=2689

design RMxprtDesign1 (RMxprt, Three Phase Induction Motor, model units mm)
machine:
  Machine: FrictionLoss=0W WindLoss=0W ReferenceSpeed=1450rpm NumberOfPoles=4 StrayLossFactor=0.01
  Stator: SkewWidth=0 NumberOfSlots=36 LaminationSectors=1 PressBoardThickness=0mm OuterDiameter=200mm InnerDiameter=135mm Length=135mm StackingFactor=0.95 SteelType=steel_1010 SlotType=4
  Rotor: OuterDiameter=134mm InnerDiameter=61.4mm Length=135mm SteelType=steel_1010 NumberOfSlots=34 SlotType=4 SkewWidth=1 CastRotor BottomSlotType=3 StackingFactor=0.95
  Shaft:
  Stator Slot: Hs0=0.59mm Hs1=0mm Hs2=17.61mm Bs0=2.5mm Bs1=5.35mm Bs2=7.95mm Rs=1.2mm ToothWidth=0mm
  Stator Winding: WindingType=Whole-Coiled WindingLayers=1 HalfTurnLength=0mm ParallelBranches=1 ConductorsPerSlot=30 CoilPitch=0 EndAdjustment=0mm BaseInnerRadius=10mm TipInnerDiameter=2mm EndClearance=0.001mm CoilWrap=0mm SlotLiner=0mm WedgeThickness=0mm LayerInsulation=0mm BottomInsulation=0mm LimitedFillFactor=0.75 WdgNumberofPriodicMultipler=2 WdgConstantTurns Wdgcoil_turns(30, 30, 30, 30, 30, 30, 30, 30, 30, 30, 30, 30, 30, 30, 30, 30, 30, 30) Wdgcoil_name(A, A, A, -C, -C, -C, B, B, B, -A, -A, -A, C, C, C, -B, -B, -B) Wdgcoil_go(4, 5, 6, 10, 11, 12, 16, 17, 18, 22, 23, 24, 28, 29, 30, 34, 35, 36) Wdgcoil_re(19, 20, 21, 25, 26, 27, 31, 32, 33, 1, 2, 3, 7, 8, 9, 13, 14, 15) NumberOfStrands=1 WireWrap=0mm InterturnInsulation=0mm WireDiameter=1.628mm WireWidth=0mm WireThickness=0mm Gauge=14
  Rotor Slot: Hs0=0.7mm Hs1=0mm Hs2=19mm Bs0=1mm Bs1=4.7mm Bs2=2.03mm Rs=0.89mm Hs01=0mm
  Rotor Winding: BarConductorType=aluminum EndLength=2mm EndRingWidth=2mm EndRingHeight=2mm EndRingConductorType=aluminum
setups:
  Setup1: TPIM Motor RatedOutputPower=4200W RatedVoltage=380V RatedSpeed=1450rpm OperatingTemperature=75cel LoadType=ConstTorque Frequency=50Hz WindingConnection=0
