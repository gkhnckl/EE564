# Ansys Electronics Desktop project, version 2017.0
materials:
  D21_50: permeability{BType=normal HUnit=A_per_meter BUnit=tesla curve (0, 0) (140, 0.4) (155, 0.45) (171, 0.5) (191, 0.55) (212, 0.6) (237, 0.65) (267, 0.7) (302, 0.75) (340, 0.8) (380, 0.85) (425, 0.9) (476, 0.95) (536, 1) (602, 1.05) (675, 1.1) (765, 1.15) (880, 1.2) (1020, 1.25) (1200, 1.3) (1450, 1.35) (1740, 1.4) (2160, 1.45) (2800, 1.5) (3850, 1.55) (5290, 1.6) (6920, 1.65) (8800, 1.7) (11000, 1.75) (13800, 1.8) (17300, 1.85) (21400, 1.9) (25000, 1.95) (30000, 2)} core_loss_type="Electrical Steel" core_loss_kh=366 core_loss_kc=0.822 core_loss_ke=0.91 mass_density=7820
  copper: permeability=0.999991 conductivity=58000000 mass_density=8933
  vacuum: permittivity=1
  D21_50_2DSF0.950: permeability{BType=normal HUnit=A_per_meter BUnit=tesla curve (0, 0) (140, 0.380009) (155, 0.42751) (171, 0.475011) (191, 0.522512) (212, 0.570013) (237, 0.617515) (267, 0.665017) (302, 0.712519) (340, 0.760021) (380, 0.807524) (425, 0.855027) (476, 0.90253) (536, 0.950034) (602, 0.997538) (675, 1.04504) (765, 1.09255) (880, 1.14006) (1020, 1.18756) (1200, 1.23508) (1450, 1.28259) (1740, 1.33011) (2160, 1.37764) (2800, 1.42518) (3850, 1.47274) (5290, 1.52033) (6920, 1.56793) (8800, 1.61555) (11000, 1.66319) (13800, 1.71087) (17300, 1.75859) (21400, 1.80634) (25000, 1.85407) (30000, 1.90188) (80000, 2.38003)} core_loss_type="Electrical Steel" core_loss_kh=385.263 core_loss_kc=0.865263 core_loss_ke=0.93364 mass_density=7429
  copper_75C: conductivity=58000000
  D21_50_3DSF0.950: permeability{BType=normal HUnit=A_per_meter BUnit=tesla curve (0, 0) (140, 0.4) (155, 0.45) (171, 0.5) (191, 0.55) (212, 0.6) (237, 0.65) (267, 0.7) (302, 0.75) (340, 0.8) (380, 0.85) (425, 0.9) (476, 0.95) (536, 1) (602, 1.05) (675, 1.1) (765, 1.15) (880, 1.2) (1020, 1.25) (1200, 1.3) (1450, 1.35) (1740, 1.4) (2160, 1.45) (2800, 1.5) (3850, 1.55) (5290, 1.6) (6920, 1.65) (8800, 1.7) (11000, 1.75) (13800, 1.8) (17300, 1.85) (21400, 1.9) (25000, 1.95) (30000, 2) (80000, 2.5)} core_loss_type="Electrical Steel" core_loss_kh=366 core_loss_kc=0.822 core_loss_ke=0.91 mass_density=7820 stacking_type=Lamination stacking_factor=0.95 stacking_direction=V(3)
  steel_1010: permittivity=1 permeability{BType=normal HUnit=A_per_meter BUnit=tesla curve (0, 0) (238.7, 0.2003) (318.3, 0.3204) (358.1, 0.40045) (437.7, 0.50055) (477.5, 0.5606) (636.6, 0.7908) (795.8, 0.931) (1114.1, 1.1014) (1273.2, 1.2016) (1591.5, 1.302) (2228.2, 1.4028) (3183.1, 1.524) (4774.6, 1.626) (6366.2, 1.698) (7957.7, 1.73) (15915.5, 1.87) (31831, 1.99) (47746.5, 2.04) (63662, 2.07) (79577.5, 2.095) (159155, 2.2) (318310, 2.4)} conductivity=2000000 lande_g_factor=2 mass_density=7872
  steel_1010_2DSF0.950: permeability{BType=normal HUnit=A_per_meter BUnit=tesla curve (0, 0) (238.7, 0.1903) (318.3, 0.3044) (358.1, 0.38045) (437.7, 0.47555) (477.5, 0.5326) (636.6, 0.7513) (795.8, 0.8845) (1114.1, 1.0464) (1273.2, 1.1416) (1591.5, 1.237) (2228.2, 1.3328) (3183.1, 1.448) (4774.6, 1.545) (6366.2, 1.6135) (7957.7, 1.644) (15915.5, 1.7775) (31831, 1.8925) (47746.5, 1.941) (63662, 1.9705) (79577.5, 1.99525) (159155, 2.1) (318310, 2.3) (1909860, 4.3)} conductivity=2000000 mass_density=7478.4
  aluminum: permeability=1.000021 conductivity=38000000 mass_density=2689
  aluminum_75C: conductivity=38000000
  JFE_Steel_20JNEH1200: core_loss_curve{50Hz (0, 0) (0.5, 0.28) (0.55, 0.34) (0.6, 0.39) (0.65, 0.45) (0.7, 0.5) (0.75, 0.56) (0.8, 0.62) (0.85, 0.68) (0.9, 0.74) (0.95, 0.81) (1, 0.88) (1.05, 0.97) (1.1, 1.05) (1.15, 1.15) (1.2, 1.25) (1.25, 1.37) (1.3, 1.5) (1.35, 1.64) (1.4, 1.79) (1.45, 1.96) (1.5, 2.14) (1.55, 2.32) (1.6, 2.51) (1.65, 2.71) (1.7, 2.9)} core_loss_curve{60Hz (0, 0) (0.5, 0.34) (0.55, 0.39) (0.6, 0.45) (0.65, 0.52) (0.7, 0.59) (0.75, 0.67) (0.8, 0.75) (0.85, 0.84) (0.9, 0.93) (0.95, 1.03) (1, 1.13) (1.05, 1.24) (1.1, 1.35) (1.15, 1.47) (1.2, 1.6) (1.25, 1.73) (1.3, 1.88) (1.35, 2.04) (1.4, 2.21) (1.45, 2.39) (1.5, 2.58) (1.55, 2.79) (1.6, 3) (1.65, 3.22) (1.7, 3.45)} core_loss_curve{100Hz (0, 0) (0.066, 0.01) (0.1, 0.028) (0.2, 0.127) (0.3, 0.274) (0.4, 0.446) (0.5, 0.639) (0.6, 0.856) (0.7, 1.09) (0.8, 1.35) (0.9, 1.62) (1, 1.92) (1.1, 2.29) (1.2, 2.71) (1.3, 3.17) (1.4, 3.72) (1.5, 4.3)} core_loss_curve{200Hz (0, 0) (0.046, 0.01) (0.1, 0.0611) (0.2, 0.269) (0.3, 0.577) (0.4, 0.977) (0.5, 1.43) (0.6, 1.92) (0.7, 2.47) (0.8, 3.08) (0.9, 3.77) (1, 4.53) (1.1, 5.4) (1.2, 6.35) (1.3, 7.4) (1.4, 8.63) (1.5, 10)} core_loss_curve{400Hz (0, 0) (0.032, 0.01) (0.1, 0.14) (0.2, 0.617) (0.3, 1.4) (0.4, 2.37) (0.5, 3.44) (0.6, 4.63) (0.7, 5.93) (0.8, 7.37) (0.9, 9.05) (1, 10.9) (1.1, 13.1) (1.2, 15.6) (1.3, 18.4) (1.4, 21.6) (1.5, 25.1)} core_loss_curve{1kHz (0, 0) (0.0153, 0.01) (0.1, 0.557) (0.2, 2.25) (0.3, 4.91) (0.4, 8.36) (0.5, 12.5) (0.6, 17.4) (0.7, 22.5) (0.8, 28.2) (0.9, 34.8) (1, 42.1) (1.1, 50.7) (1.2, 60.2) (1.3, 70.9) (1.4, 83.5) (1.5, 98.4)} core_loss_curve{2kHz (0, 0) (0.01, 0.014) (0.1, 1.57) (0.2, 6.05) (0.3, 13.3) (0.4, 22.5) (0.5, 33.2) (0.6, 45.6) (0.7, 59.6) (0.8, 74.9) (0.9, 92.1) (0.94, 100)} core_loss_curve{5kHz (0, 0) (0.01, 0.077) (0.1, 6.8) (0.15, 14.7) (0.2, 24.4) (0.3, 51) (0.4, 86.9) (0.43, 100)} core_loss_curve{10kHz (0, 0) (0.01, 0.255) (0.05, 6.7) (0.1, 20.9) (0.15, 45.2) (0.2, 77.3) (0.23, 100)} permeability{BType=normal HUnit=A_per_meter BUnit=tesla curve (0, 0) (10, 0.01) (19.6, 0.05) (26.6, 0.1) (30.9, 0.15) (33.9, 0.2) (36.4, 0.25) (38.8, 0.3) (41.4, 0.3501) (44, 0.4001) (46.6, 0.45) (49.3, 0.5001) (52, 0.5501) (54.9, 0.6001) (57.9, 0.6501) (61.2, 0.7001) (65, 0.7501) (69.1, 0.8001) (73.9, 0.8501) (79.2, 0.9001) (85.2, 0.9501) (92.3, 1.0001) (101, 1.0501) (112, 1.1001) (127, 1.1502) (146, 1.2002) (172, 1.2502) (209, 1.3003) (263, 1.3503) (357, 1.4004) (554, 1.4507) (1060, 1.5013) (1900, 1.5524) (2910, 1.6037) (4080, 1.6551) (5000, 1.6854) (5670, 1.7071) (7900, 1.7599) (10000, 1.7944) (11200, 1.8141) (16000, 1.8701) (24100, 1.9303) (42300, 2.0032) (80000, 2.0805)} conductivity=1818182 core_loss_type="Electrical Steel" core_loss_kh=173.2958 core_loss_kc=0.085956172 core_loss_ke=2.0678793 mass_density=7650
  JFE_Steel_20JNEH1200_2DSF0.950: permeability{BType=normal HUnit=A_per_meter BUnit=tesla curve (0, 0) (10, 0.00950063) (19.6, 0.0475012) (26.6, 0.0950017) (30.9, 0.142502) (33.9, 0.190002) (36.4, 0.237502) (38.8, 0.285002) (41.4, 0.332598) (44, 0.380098) (46.6, 0.427503) (49.3, 0.475098) (52, 0.522598) (54.9, 0.570098) (57.9, 0.617599) (61.2, 0.665099) (65, 0.712599) (69.1, 0.760099) (73.9, 0.8076) (79.2, 0.8551) (85.2, 0.9026) (92.3, 0.950101) (101, 0.997601) (112, 1.0451) (127, 1.0927) (146, 1.1402) (172, 1.1877) (209, 1.2353) (263, 1.2828) (357, 1.3304) (554, 1.3782) (1060, 1.4263) (1900, 1.4749) (2910, 1.5237) (4080, 1.5726) (5000, 1.60144) (5670, 1.6221) (7900, 1.6724) (10000, 1.70531) (11200, 1.7241) (16000, 1.7776) (24100, 1.8353) (42300, 1.9057) (80000, 1.9815) (457000, 2.73954)} conductivity=1818180 core_loss_type="Electrical Steel" core_loss_kh=182.417 core_loss_kc=0.0904802 core_loss_ke=2.1216 mass_density=7267.5
  JFE_Steel_20JNEH1200_3DSF0.950: permeability{BType=normal HUnit=A_per_meter BUnit=tesla curve (0, 0) (10, 0.01) (19.6, 0.05) (26.6, 0.1) (30.9, 0.15) (33.9, 0.2) (36.4, 0.25) (38.8, 0.3) (41.4, 0.3501) (44, 0.4001) (46.6, 0.45) (49.3, 0.5001) (52, 0.5501) (54.9, 0.6001) (57.9, 0.6501) (61.2, 0.7001) (65, 0.7501) (69.1, 0.8001) (73.9, 0.8501) (79.2, 0.9001) (85.2, 0.9501) (92.3, 1.0001) (101, 1.0501) (112, 1.1001) (127, 1.1502) (146, 1.2002) (172, 1.2502) (209, 1.3003) (263, 1.3503) (357, 1.4004) (554, 1.4507) (1060, 1.5013) (1900, 1.5524) (2910, 1.6037) (4080, 1.6551) (5000, 1.6854) (5670, 1.7071) (7900, 1.7599) (10000, 1.7944) (11200, 1.8141) (16000, 1.8701) (24100, 1.9303) (42300, 2.0032) (80000, 2.0805) (457000, 2.8535)} conductivity=1818180 core_loss_type="Electrical Steel" core_loss_kh=173.296 core_loss_kc=0.0859562 core_loss_ke=2.06788 mass_density=7650 stacking_type=Lamination stacking_factor=0.95 stacking_direction=V(3)
  steel_1010_3DSF0.950: permeability{BType=normal HUnit=A_per_meter BUnit=tesla curve (0, 0) (238.7, 0.2003) (318.3, 0.3204) (358.1, 0.40045) (437.7, 0.50055) (477.5, 0.5606) (636.6, 0.7908) (795.8, 0.931) (1114.1, 1.1014) (1273.2, 1.2016) (1591.5, 1.302) (2228.2, 1.4028) (3183.1, 1.524) (4774.6, 1.626) (6366.2, 1.698) (7957.7, 1.73) (15915.5, 1.87) (31831, 1.99) (47746.5, 2.04) (63662, 2.07) (79577.5, 2.095) (159155, 2.2) (318310, 2.4) (1909860, 4.4)} conductivity=2000000 mass_density=7872 stacking_type=Lamination stacking_factor=0.95 stacking_direction=V(3)

design RMxprtDesign1 (RMxprt, Three Phase Induction Motor, model units mm)
machine:
  Machine: FrictionLoss=0W WindLoss=0W ReferenceSpeed=742rpm NumberOfPoles=8 StrayLossFactor=0.01
  Stator: SkewWidth=0 NumberOfSlots=48 LaminationSectors=1 PressBoardThickness=0mm OuterDiameter=680mm InnerDiameter=544mm Length=337mm StackingFactor=0.96 SteelType=JFE_Steel_20JNEH1200 SlotType=4
  Rotor: OuterDiameter=542mm InnerDiameter=360mm Length=336.9mm SteelType=JFE_Steel_20JNEH1200 NumberOfSlots=57 SlotType=1 SkewWidth=1 CastRotor BottomSlotType=3 StackingFactor=0.96
  Shaft:
  Stator Slot: Hs0=2mm Hs1=2mm Hs2=30mm Bs0=10mm Bs1=18mm Bs2=18mm Rs=0mm ToothWidth=0mm
  Stator Winding: WindingType=Half-Coiled WindingLayers=1 HalfTurnLength=0mm ParallelBranches=1 ConductorsPerSlot=4 CoilPitch=0 EndAdjustment=0mm BaseInnerRadius=1mm TipInnerDiameter=1mm EndClearance=0.001mm CoilWrap=0mm SlotLiner=0mm WedgeThickness=0mm LayerInsulation=0mm BottomInsulation=0mm LimitedFillFactor=0.75 WdgNumberofPriodicMultipler=2 WdgConstantTurns Wdgcoil_turns(30, 30, 30, 30, 30, 30, 30, 30, 30, 30, 30, 30, 30, 30, 30, 30, 30, 30) Wdgcoil_name(A, A, A, -C, -C, -C, B, B, B, -A, -A, -A, C, C, C, -B, -B, -B) Wdgcoil_go(4, 5, 6, 10, 11, 12, 16, 17, 18, 22, 23, 24, 28, 29, 30, 34, 35, 36) Wdgcoil_re(19, 20, 21, 25, 26, 27, 31, 32, 33, 1, 2, 3, 7, 8, 9, 13, 14, 15) NumberOfStrands=44 WireWrap=0mm InterturnInsulation=0mm WireDiameter=1.45mm WireWidth=2.44mm WireThickness=1.29mm Gauge=15
  Rotor Slot: Hs0=1mm Hs1=0mm Hs2=50mm Bs0=5mm Bs1=10mm Bs2=8mm Rs=5mm Hs01=0mm
  Rotor Winding: BarConductorType=copper EndLength=20mm EndRingWidth=20mm EndRingHeight=60mm EndRingConductorType=copper
setups:
  Setup1: TPIM Motor RatedOutputPower=250000W RatedVoltage=400V RatedSpeed=742rpm OperatingTemperature=75cel LoadType=ConstPower Frequency=50Hz WindingConnection=0

design RMxprtDesign2 (RMxprt, Three Phase Induction Motor, model units mm)
machine:
  Machine: FrictionLoss=0W WindLoss=0W ReferenceSpeed=742rpm NumberOfPoles=8 StrayLossFactor=0.01
  Stator: SkewWidth=0 NumberOfSlots=48 LaminationSectors=1 PressBoardThickness=0mm OuterDiameter=647mm InnerDiameter=503.1mm Length=311mm StackingFactor=0.96 SteelType=steel_1010 SlotType=4
  Rotor: OuterDiameter=501.1mm InnerDiameter=150mm Length=311mm SteelType=steel_1010 NumberOfSlots=57 SlotType=1 SkewWidth=1 CastRotor BottomSlotType=3 StackingFactor=0.96
  Shaft:
  Stator Slot: Hs0=2mm Hs1=0mm Hs2=28.6mm Bs0=6mm Bs1=19.1mm Bs2=19.1mm Rs=0mm ToothWidth=0mm
  Stator Winding: WindingType=Half-Coiled WindingLayers=1 HalfTurnLength=0mm ParallelBranches=1 ConductorsPerSlot=4 CoilPitch=0 EndAdjustment=0mm BaseInnerRadius=1mm TipInnerDiameter=1mm EndClearance=0.001mm CoilWrap=0mm SlotLiner=0mm WedgeThickness=0mm LayerInsulation=0mm BottomInsulation=0mm LimitedFillFactor=0.75 WdgNumberofPriodicMultipler=2 WdgConstantTurns Wdgcoil_turns(30, 30, 30, 30, 30, 30, 30, 30, 30, 30, 30, 30, 30, 30, 30, 30, 30, 30) Wdgcoil_name(A, A, A, -C, -C, -C, B, B, B, -A, -A, -A, C, C, C, -B, -B, -B) Wdgcoil_go(4, 5, 6, 10, 11, 12, 16, 17, 18, 22, 23, 24, 28, 29, 30, 34, 35, 36) Wdgcoil_re(19, 20, 21, 25, 26, 27, 31, 32, 33, 1, 2, 3, 7, 8, 9, 13, 14, 15) NumberOfStrands=40 WireWrap=0mm InterturnInsulation=0mm WireDiameter=1.45mm WireWidth=2.44mm WireThickness=1.29mm Gauge=15
  Rotor Slot: Hs0=1mm Hs1=0mm Hs2=50mm Bs0=5mm Bs1=10mm Bs2=8mm Rs=5mm Hs01=0mm
  Rotor Winding: BarConductorType=copper EndLength=20mm EndRingWidth=20mm EndRingHeight=60mm EndRingConductorType=copper
setups:
  Setup1: TPIM Motor RatedOutputPower=250000W RatedVoltage=400V RatedSpeed=742rpm OperatingTemperature=75cel LoadType=ConstPower Frequency=50Hz WindingConnection=0
