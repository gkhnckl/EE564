# Ansys Electronics Desktop project, version 2017.0
materials:
  D21_50: permeability{BType=normal HUnit=A_per_meter BUnit=tesla curve (0, 0) (140, 0.4) (155, 0.45) (171, 0.5) (191, 0.55) (212, 0.6) (237, 0.65) (267, 0.7) (302, 0.75) (340, 0.8) (380, 0.85) (425, 0.9) (476, 0.95) (536, 1) (602, 1.05) (675, 1.1) (765, 1.15) (880, 1.2) (1020, 1.25) (1200, 1.3) (1450, 1.35) (1740, 1.4) (2160, 1.45) (2800, 1.5) (3850, 1.55) (5290, 1.6) (6920, 1.65) (8800, 1.7) (11000, 1.75) (13800, 1.8) (17300, 1.85) (21400, 1.9) (25000, 1.95) (30000, 2)} core_loss_type="Electrical Steel" core_loss_kh=366 core_loss_kc=0.822 core_loss_ke=0.91 mass_density=7820
  copper: permeability=0.999991 conductivity=58000000 mass_density=8933
  vacuum: permittivity=1
  D21_50_2DSF0.950: permeability{BType=normal HUnit=A_per_meter BUnit=tesla curve (0, 0) (140, 0.380009) (155, 0.42751) (171, 0.475011) (191, 0.522512) (212, 0.570013) (237, 0.617515) (267, 0.665017) (302, 0.712519) (340, 0.760021) (380, 0.807524) (425, 0.855027) (476, 0.90253) (536, 0.950034) (602, 0.997538) (675, 1.04504) (765, 1.09255) (880, 1.14006) (1020, 1.18756) (1200, 1.23508) (1450, 1.28259) (1740, 1.33011) (2160, 1.37764) (2800, 1.42518) (3850, 1.47274) (5290, 1.52033) (6920, 1.56793) (8800, 1.61555) (11000, 1.66319) (13800, 1.71087) (17300, 1.75859) (21400, 1.80634) (25000, 1.85407) (30000, 1.90188) (80000, 2.38003)} core_loss_type="Electrical Steel" core_loss_kh=385.263 core_loss_kc=0.865263 core_loss_ke=0.93364 mass_density=7429
  copper_75C: conductivity=58000000
  D21_50_3DSF0.950: permeability{BType=normal HUnit=A_per_meter BUnit=tesla curve (0, 0) (140, 0.4) (155, 0.45) (171, 0.5) (191, 0.55) (212, 0.6) (237, 0.65) (267, 0.7) (302, 0.75) (340, 0.8) (380, 0.85) (425, 0.9) (476, 0.95) (536, 1) (602, 1.05) (675, 1.1) (765, 1.15) (880, 1.2) (1020, 1.25) (1200, 1.3) (1450, 1.35) (1740, 1.4) (2160, 1.45) (2800, 1.5) (3850, 1.55) (5290, 1.6) (6920, 1.65) (8800, 1.7) (11000, 1.75) (13800, 1.8) (17300, 1.85) (21400, 1.9) (25000, 1.95) (30000, 2) (80000, 2.5)} core_loss_type="Electrical Steel" core_loss_kh=366 core_loss_kc=0.822 core_loss_ke=0.91 mass_density=7820 stacking_type=Lamination stacking_factor=0.95 stacking_direction=V(3)
  steel_1010: permittivity=1 permeability{BType=normal HUnit=A_per_meter BUnit=tesla curve (0, 0) (238.7, 0.2003) (318.3, 0.3204) (358.1, 0.40045) (437.7, 0.50055) (477.5, 0.5606) (636.6, 0.7908) (795.8, 0.931) (1114.1, 1.1014) (1273.2, 1.2016) (1591.5, 1.302) (2228.2, 1.4028) (3183.1, 1.524) (4774.6, 1.626) (6366.2, 1.698) (7957.7, 1.73) (15915.5, 1.87) (31831, 1.99) (47746.5, 2.04) (63662, 2.07) (79577.5, 2.095) (159155, 2.2) (318310, 2.4)} conductivity=2000000 lande_g_factor=2 mass_density=7872
  steel_1010_2DSF0.950: permeability{BType=normal HUnit=A_per_meter BUnit=tesla curve (0, 0) (238.7, 0.1903) (318.3, 0.3044) (358.1, 0.38045) (437.7, 0.47555) (477.5, 0.5326) (636.6, 0.7513) (795.8, 0.8845) (1114.1, 1.0464) (1273.2, 1.1416) (1591.5, 1.237) (2228.2, 1.3328) (3183.1, 1.448) (4774.6, 1.545) (6366.2, 1.6135) (7957.7, 1.644) (15915.5, 1.7775) (31831, 1.8925) (47746.5, 1.941) (63662, 1.9705) (79577.5, 1.99525) (159155, 2.1) (318310, 2.3) (1909860, 4.3)} conductivity=2000000 mass_density=7478.4
  aluminum: permeability=1.000021 conductivity=38000000 mass_density=2689
  aluminum_75C: conductivity=38000000
  JFE_Steel_20JNEH1200: core_loss_curve{50Hz (0, 0) (0.5, 0.28) (0.55, 0.34) (0.6, 0.39) (0.65, 0.45) (0.7, 0.5) (0.75, 0.56) (0.8, 0.62) (0.85, 0.68) (0.9, 0.74) (0.95, 0.81) (1, 0.88) (1.05, 0.97) (1.1, 1.05) (1.15, 1.15) (1.2, 1.25) (1.25, 1.37) (1.3, 1.5) (1.35, 1.64) (1.4, 1.79) (1.45, 1.96) (1.5, 2.14) (1.55, 2.32) (1.6, 2.51) (1.65, 2.71) (1.7, 2.9)} core_loss_curve{60Hz (0, 0) (0.5, 0.34) (0.55, 0.39) (0.6, 0.45) (0.65, 0.52) (0.7, 0.59) (0.75, 0.67) (0.8, 0.75) (0.85, 0.84) (0.9, 0.93) (0.95, 1.03) (1, 1.13) (1.05, 1.24) (1.1, 1.35) (1.15, 1.47) (1.2, 1.6) (1.25, 1.73) (1.3, 1.88) (1.35, 2.04) (1.4, 2.21) (1.45, 2.39) (1.5, 2.58) (1.55, 2.79) (1.6, 3) (1.65, 3.22) (1.7, 3.45)} core_loss_curve{100Hz (0, 0) (0.066, 0.01) (0.1, 0.028) (0.2, 0.127) (0.3, 0.274) (0.4, 0.446) (0.5, 0.639) (0.6, 0.856) (0.7, 1.09) (0.8, 1.35) (0.9, 1.62) (1, 1.92) (1.1, 2.29) (1.2, 2.71) (1.3, 3.17) (1.4, 3.72) (1.5, 4.3)} core_loss_curve{200Hz (0, 0) (0.046, 0.01) (0.1, 0.0611) (0.2, 0.269) (0.3, 0.577) (0.4, 0.977) (0.5, 1.43) (0.6, 1.92) (0.7, 2.47) (0.8, 3.08) (0.9, 3.77) (1, 4.53) (1.1, 5.4) (1.2, 6.35) (1.3, 7.4) (1.4, 8.63) (1.5, 10)} core_loss_curve{400Hz (0, 0) (0.032, 0.01) (0.1, 0.14) (0.2, 0.617) (0.3, 1.4) (0.4, 2.37) (0.5, 3.44) (0.6, 4.63) (0.7, 5.93) (0.8, 7.37) (0.9, 9.05) (1, 10.9) (1.1, 13.1) (1.2, 15.6) (1.3, 18.4) (1.4, 21.6) (1.5, 25.1)} core_loss_curve{1kHz (0, 0) (0.0153, 0.01) (0.1, 0.557) (0.2, 2.25) (0.3, 4.91) (0.4, 8.36) (0.5, 12.5) (0.6, 17.4) (0.7, 22.5) (0.8, 28.2) (0.9, 34.8) (1, 42.1) (1.1, 50.7) (1.2, 60.2) (1.3, 70.9) (1.4, 83.5) (1.5, 98.4)} core_loss_curve{2kHz (0, 0) (0.01, 0.014) (0.1, 1.57) (0.2, 6.05) (0.3, 13.3) (0.4, 22.5) (0.5, 33.2) (0.6, 45.6) (0.7, 59.6) (0.8, 74.9) (0.9, 92.1) (0.94, 100)} core_loss_curve{5kHz (0, 0) (0.01, 0.077) (0.1, 6.8) (0.15, 14.7) (0.2, 24.4) (0.3, 51) (0.4, 86.9) (0.43, 100)} core_loss_curve{10kHz (0, 0) (0.01, 0.255) (0.05, 6.7) (0.1, 20.9) (0.15, 45.2) (0.2, 77.3) (0.23, 100)} permeability{BType=normal HUnit=A_per_meter BUnit=tesla curve (0, 0) (10, 0.01) (19.6, 0.05) (26.6, 0.1) (30.9, 0.15) (33.9, 0.2) (36.4, 0.25) (38.8, 0.3) (41.4, 0.3501) (44, 0.4001) (46.6, 0.45) (49.3, 0.5001) (52, 0.5501) (54.9, 0.6001) (57.9, 0.6501) (61.2, 0.7001) (65, 0.7501) (69.1, 0.8001) (73.9, 0.8501) (79.2, 0.9001) (85.2, 0.9501) (92.3, 1.0001) (101, 1.0501) (112, 1.1001) (127, 1.1502) (146, 1.2002) (172, 1.2502) (209, 1.3003) (263, 1.3503) (357, 1.4004) (554, 1.4507) (1060, 1.5013) (1900, 1.5524) (2910, 1.6037) (4080, 1.6551) (5000, 1.6854) (5670, 1.7071) (7900, 1.7599) (10000, 1.7944) (11200, 1.8141) (16000, 1.8701) (24100, 1.9303) (42300, 2.0032) (80000, 2.0805)} conductivity=1818182 core_loss_type="Electrical Steel" core_loss_kh=173.2958 core_loss_kc=0.085956172 core_loss_ke=2.0678793 mass_density=7650
  JFE_Steel_20JNEH1200_2DSF0.950: permeability{BType=normal HUnit=A_per_meter BUnit=tesla curve (0, 0) (10, 0.00950063) (19.6, 0.0475012) (26.6, 0.0950017) (30.9, 0.142502) (33.9, 0.190002) (36.4, 0.237502) (38.8, 0.285002) (41.4, 0.332598) (44, 0.380098) (46.6, 0.427503) (49.3, 0.475098) (52, 0.522598) (54.9, 0.570098) (57.9, 0.617599) (61.2, 0.665099) (65, 0.712599) (69.1, 0.760099) (73.9, 0.8076) (79.2, 0.8551) (85.2, 0.9026) (92.3, 0.950101) (101, 0.997601) (112, 1.0451) (127, 1.0927) (146, 1.1402) (172, 1.1877) (209, 1.2353) (263, 1.2828) (357, 1.3304) (554, 1.3782) (1060, 1.4263) (1900, 1.4749) (2910, 1.5237) (4080, 1.5726) (5000, 1.60144) (5670, 1.6221) (7900, 1.6724) (10000, 1.70531) (11200, 1.7241) (16000, 1.7776) (24100, 1.8353) (42300, 1.9057) (80000, 1.9815) (457000, 2.73954)} conductivity=1818180 core_loss_type="Electrical Steel" core_loss_kh=182.417 core_loss_kc=0.0904802 core_loss_ke=2.1216 mass_density=7267.5
  JFE_Steel_20JNEH1200_3DSF0.950: permeability{BType=normal HUnit=A_per_meter BUnit=tesla curve (0, 0) (10, 0.01) (19.6, 0.05) (26.6, 0.1) (30.9, 0.15) (33.9, 0.2) (36.4, 0.25) (38.8, 0.3) (41.4, 0.3501) (44, 0.4001) (46.6, 0.45) (49.3, 0.5001) (52, 0.5501) (54.9, 0.6001) (57.9, 0.6501) (61.2, 0.7001) (65, 0.7501) (69.1, 0.8001) (73.9, 0.8501) (79.2, 0.9001) (85.2, 0.9501) (92.3, 1.0001) (101, 1.0501) (112, 1.1001) (127, 1.1502) (146, 1.2002) (172, 1.2502) (209, 1.3003) (263, 1.3503) (357, 1.4004) (554, 1.4507) (1060, 1.5013) (1900, 1.5524) (2910, 1.6037) (4080, 1.6551) (5000, 1.6854) (5670, 1.7071) (7900, 1.7599) (10000, 1.7944) (11200, 1.8141) (16000, 1.8701) (24100, 1.9303) (42300, 2.0032) (80000, 2.0805) (457000, 2.8535)} conductivity=1818180 core_loss_type="Electrical Steel" core_loss_kh=173.296 core_loss_kc=0.0859562 core_loss_ke=2.06788 mass_density=7650 stacking_type=Lamination stacking_factor=0.95 stacking_direction=V(3)
  steel_1010_3DSF0.950: permeability{BType=normal HUnit=A_per_meter BUnit=tesla curve (0, 0) (238.7, 0.2003) (318.3, 0.3204) (358.1, 0.40045) (437.7, 0.50055) (477.5, 0.5606) (636.6, 0.7908) (795.8, 0.931) (1114.1, 1.1014) (1273.2, 1.2016) (1591.5, 1.302) (2228.2, 1.4028) (3183.1, 1.524) (4774.6, 1.626) (6366.2, 1.698) (7957.7, 1.73) (15915.5, 1.87) (31831, 1.99) (47746.5, 2.04) (63662, 2.07) (79577.5, 2.095) (159155, 2.2) (318310, 2.4) (1909860, 4.4)} conductivity=2000000 mass_density=7872 stacking_type=Lamination stacking_factor=0.95 stacking_direction=V(3)
  JFE_Steel_20JNEH1200_2DSF0.960: permeability{BType=normal HUnit=A_per_meter BUnit=tesla curve (0, 0) (10, 0.0096005) (19.6, 0.048001) (26.6, 0.0960013) (30.9, 0.144002) (33.9, 0.192002) (36.4, 0.240002) (38.8, 0.288002) (41.4, 0.336098) (44, 0.384098) (46.6, 0.432002) (49.3, 0.480098) (52, 0.528099) (54.9, 0.576099) (57.9, 0.624099) (61.2, 0.672099) (65, 0.720099) (69.1, 0.768099) (73.9, 0.8161) (79.2, 0.8641) (85.2, 0.9121) (92.3, 0.960101) (101, 1.0081) (112, 1.0561) (127, 1.1042) (146, 1.1522) (172, 1.2002) (209, 1.2483) (263, 1.2963) (357, 1.3444) (554, 1.3927) (1060, 1.4413) (1900, 1.4904) (2910, 1.5397) (4080, 1.5891) (5000, 1.61824) (5670, 1.6391) (7900, 1.6899) (10000, 1.72313) (11200, 1.7421) (16000, 1.7961) (24100, 1.8543) (42300, 1.9252) (80000, 2.0013) (457000, 2.76233)} conductivity=1818180 core_loss_type="Electrical Steel" core_loss_kh=180.516 core_loss_kc=0.0895377 core_loss_ke=2.11052 mass_density=7344

design RMxprtDesign1 (RMxprt, Three Phase Induction Motor, model units mm)
variables:
  slot_width = 15.5mm
  slot_depth = 39mm
  dia_out_stator = 678.7mm
  dia_in_stator = 524.8mm
  l_act = 324.5mm
  number_of_cond_per_slot = 4
  number_of_strands_per_cond = 46
  dia_out_rotor = 522.8mm
  dia_strand = 1.45
machine:
  Machine: FrictionLoss=1000W WindLoss=1000W ReferenceSpeed=742rpm NumberOfPoles=8 StrayLossFactor=0.01
  Stator: SkewWidth=0 NumberOfSlots=48 LaminationSectors=1 PressBoardThickness=0mm OuterDiameter=dia_out_stator InnerDiameter=dia_in_stator Length=l_act StackingFactor=0.96 SteelType=JFE_Steel_20JNEH1200 SlotType=4
  Rotor: OuterDiameter=dia_out_rotor InnerDiameter=100mm Length=l_act SteelType=JFE_Steel_20JNEH1200 NumberOfSlots=57 SlotType=1 SkewWidth=1 CastRotor BottomSlotType=3 StackingFactor=0.96
  Shaft: MagneticShaft
  Stator Slot: Hs0=1mm Hs1=1mm Hs2=slot_depth Bs0=10mm Bs1=slot_width Bs2=slot_width Rs=0mm ToothWidth=0mm
  Stator Winding: WindingType=Whole-Coiled WindingLayers=1 HalfTurnLength=0mm ParallelBranches=1 ConductorsPerSlot=number_of_cond_per_slot CoilPitch=0 EndAdjustment=0mm BaseInnerRadius=1mm TipInnerDiameter=1mm EndClearance=0.001mm CoilWrap=0mm SlotLiner=0mm WedgeThickness=0mm LayerInsulation=0mm BottomInsulation=0mm LimitedFillFactor=0.75 WdgNumberofPriodicMultipler=2 WdgConstantTurns Wdgcoil_turns(30, 30, 30, 30, 30, 30, 30, 30, 30, 30, 30, 30, 30, 30, 30, 30, 30, 30) Wdgcoil_name(A, A, A, -C, -C, -C, B, B, B, -A, -A, -A, C, C, C, -B, -B, -B) Wdgcoil_go(4, 5, 6, 10, 11, 12, 16, 17, 18, 22, 23, 24, 28, 29, 30, 34, 35, 36) Wdgcoil_re(19, 20, 21, 25, 26, 27, 31, 32, 33, 1, 2, 3, 7, 8, 9, 13, 14, 15) NumberOfStrands=46 WireWrap=0mm InterturnInsulation=0mm WireDiameter="dia_strand mm" WireWidth=2.44mm WireThickness=1.29mm Gauge=0
  Rotor Slot: Hs0=1mm Hs1=0mm Hs2=27.5mm Bs0=5mm Bs1=10mm Bs2=8mm Rs=5mm Hs01=0mm
  Rotor Winding: BarConductorType=copper EndLength=5mm EndRingWidth=10mm EndRingHeight=60mm EndRingConductorType=copper
setups:
  Setup1: TPIM Motor RatedOutputPower=250000W RatedVoltage=400V RatedSpeed=742rpm OperatingTemperature=75cel LoadType=ConstPower Frequency=50Hz WindingConnection=0

design Maxwell2DDesign1 (Maxwell 2D, Transient, XY geometry, model units mm)
options: ModelDepth=324.5mm Multiplier=fractions
variables:
  fractions = 1
  slot_width = 15.5mm
  slot_depth = 39mm
  dia_out_stator = 678.7mm
  dia_in_stator = 524.8mm
  l_act = 324.5mm
  number_of_cond_per_slot = 4
  number_of_strands_per_cond = 46
  dia_out_rotor = 522.8mm
  dia_strand = 1.45
geometry:
  Band [vacuum] = user_primitive(RMxprt/Band, DiaGap=(dia_in_stator + dia_out_rotor)/2, DiaYoke=100mm, Length=0mm, SegAngle=0.83333333deg, Fractions=1, HalfAxial=0, InfoCore=0)
  Shaft [JFE_Steel_20JNEH1200_2DSF0.960] = user_primitive(RMxprt/Band, DiaGap=(dia_in_stator + dia_out_rotor)/2, DiaYoke=100mm, Length=0mm, SegAngle=0.83333333deg, Fractions=1, HalfAxial=0, InfoCore=100)
  OuterRegion [vacuum] = user_primitive(RMxprt/Band, DiaGap=(dia_in_stator + dia_out_rotor)/2, DiaYoke=dia_out_stator, Length=0mm, SegAngle=0.83333333deg, Fractions=fractions, HalfAxial=0, InfoCore=100)
  Tool = user_primitive(RMxprt/Band, DiaGap=(dia_in_stator + dia_out_rotor)/2, DiaYoke=dia_out_stator, Length=0mm, SegAngle=0.83333333deg, Fractions=fractions, HalfAxial=0, InfoCore=1)
  Stator [JFE_Steel_20JNEH1200_2DSF0.960] = user_primitive(RMxprt/SlotCore, DiaGap=dia_in_stator, DiaYoke=dia_out_stator, Length=0mm, Skew=0deg, Slots=48, SlotType=4, Hs0=1mm, Hs01=0mm, Hs1=1mm, Hs2=slot_depth, Bs0=10mm, Bs1=slot_width, Bs2=slot_width, Rs=0mm, FilletType=0, HalfSlot=0, SegAngle=15deg, LenRegion=0mm, InfoCore=0)
  Coil_0 [copper] = user_primitive(RMxprt/LapCoil, DiaGap=dia_in_stator, DiaYoke=dia_out_stator, Length=0mm, Skew=0deg, Slots=48, SlotType=4, Hs0=1mm, Hs1=1mm, Hs2=slot_depth, Bs0=10mm, Bs1=slot_width, Bs2=slot_width, Rs=0mm, FilletType=0, Layers=1, CoilPitch=2, EndExt=0mm, SpanExt=0mm, BendAngle=0deg, SegAngle=10deg, LenRegion=0mm, InfoCoil=2)
  Coil_1..Coil_47 [copper] = Coil_0.duplicate_around_axis(axis=Z, angle=7.5deg, total=48)
  Rotor [JFE_Steel_20JNEH1200_2DSF0.960] = user_primitive(RMxprt/SlotCore, DiaGap=dia_out_rotor, DiaYoke=100mm, Length=0mm, Skew=0deg, Slots=57, SlotType=1, Hs0=1mm, Hs01=0mm, Hs1=0mm, Hs2=27.5mm, Bs0=5mm, Bs1=10mm, Bs2=8mm, Rs=5mm, FilletType=0, HalfSlot=0, SegAngle=15deg, LenRegion=0mm, InfoCore=0)
  Bar [copper_75C] = user_primitive(RMxprt/SquirrelCage, DiaGap=dia_out_rotor, DiaYoke=100mm, Length=0mm, Skew=0deg, Slots=57, SlotType=1, Hs0=1mm, Hs01=0mm, Hs1=0mm, Hs2=27.5mm, Bs0=5mm, Bs1=10mm, Bs2=8mm, Rs=5mm, FilletType=0, HalfSlot=0, BarEndExt=5mm, RingLength=10mm, RingHeight=60mm, RingDiaGap=0mm, CastRotor=1, SegAngle=15deg, LenRegion=0mm, InfoCoil=0)
  Tool_1 = Tool.copy()
  Bar.subtract(Tool_1)
  Bar_Separate1..Bar_Separate56 [copper_75C] = Bar.separate_bodies()
  InnerRegion [vacuum] = user_primitive(RMxprt/SlotCore, DiaGap=dia_out_rotor, DiaYoke=100mm, Length=0mm, Skew=0deg, Slots=57, SlotType=1, Hs0=1mm, Hs01=0mm, Hs1=0mm, Hs2=27.5mm, Bs0=5mm, Bs1=10mm, Bs2=8mm, Rs=5mm, FilletType=0, HalfSlot=0, SegAngle=15deg, LenRegion=0mm, InfoCore=100)
  Tool_2 = Tool.copy()
  Band.subtract(Tool_2)
  Tool_3 = Tool.copy()
  InnerRegion.subtract(Tool_3)
  Tool_4 = Tool.copy()
  Shaft.subtract(Tool_4)
  Tool_5 = Tool.copy()
  Stator.subtract(Tool_5)
  Tool_6 = Tool.copy()
  Coil_0.subtract(Tool_6)
  Tool_7 = Tool.copy()
  Coil_1.subtract(Tool_7)
  Tool_8 = Tool.copy()
  Coil_2.subtract(Tool_8)
  Tool_9 = Tool.copy()
  Coil_3.subtract(Tool_9)
  Tool_10 = Tool.copy()
  Coil_4.subtract(Tool_10)
  Tool_11 = Tool.copy()
  Coil_5.subtract(Tool_11)
  Tool_12 = Tool.copy()
  Coil_6.subtract(Tool_12)
  Tool_13 = Tool.copy()
  Coil_7.subtract(Tool_13)
  Tool_14 = Tool.copy()
  Coil_8.subtract(Tool_14)
  Tool_15 = Tool.copy()
  Coil_9.subtract(Tool_15)
  Tool_16 = Tool.copy()
  Coil_10.subtract(Tool_16)
  Tool_17 = Tool.copy()
  Coil_11.subtract(Tool_17)
  Tool_18 = Tool.copy()
  Coil_12.subtract(Tool_18)
  Tool_19 = Tool.copy()
  Coil_13.subtract(Tool_19)
  Tool_20 = Tool.copy()
  Coil_14.subtract(Tool_20)
  Tool_21 = Tool.copy()
  Coil_15.subtract(Tool_21)
  Tool_22 = Tool.copy()
  Coil_16.subtract(Tool_22)
  Tool_23 = Tool.copy()
  Coil_17.subtract(Tool_23)
  Tool_24 = Tool.copy()
  Coil_18.subtract(Tool_24)
  Tool_25 = Tool.copy()
  Coil_19.subtract(Tool_25)
  Tool_26 = Tool.copy()
  Coil_20.subtract(Tool_26)
  Tool_27 = Tool.copy()
  Coil_21.subtract(Tool_27)
  Tool_28 = Tool.copy()
  Coil_22.subtract(Tool_28)
  Tool_29 = Tool.copy()
  Coil_23.subtract(Tool_29)
  Tool_30 = Tool.copy()
  Coil_24.subtract(Tool_30)
  Tool_31 = Tool.copy()
  Coil_25.subtract(Tool_31)
  Tool_32 = Tool.copy()
  Coil_26.subtract(Tool_32)
  Tool_33 = Tool.copy()
  Coil_27.subtract(Tool_33)
  Tool_34 = Tool.copy()
  Coil_28.subtract(Tool_34)
  Tool_35 = Tool.copy()
  Coil_29.subtract(Tool_35)
  Tool_36 = Tool.copy()
  Coil_30.subtract(Tool_36)
  Tool_37 = Tool.copy()
  Coil_31.subtract(Tool_37)
  Tool_38 = Tool.copy()
  Coil_32.subtract(Tool_38)
  Tool_39 = Tool.copy()
  Coil_33.subtract(Tool_39)
  Tool_40 = Tool.copy()
  Coil_34.subtract(Tool_40)
  Tool_41 = Tool.copy()
  Coil_35.subtract(Tool_41)
  Tool_42 = Tool.copy()
  Coil_36.subtract(Tool_42)
  Tool_43 = Tool.copy()
  Coil_37.subtract(Tool_43)
  Tool_44 = Tool.copy()
  Coil_38.subtract(Tool_44)
  Tool_45 = Tool.copy()
  Coil_39.subtract(Tool_45)
  Tool_46 = Tool.copy()
  Coil_40.subtract(Tool_46)
  Tool_47 = Tool.copy()
  Coil_41.subtract(Tool_47)
  Tool_48 = Tool.copy()
  Coil_42.subtract(Tool_48)
  Tool_49 = Tool.copy()
  Coil_43.subtract(Tool_49)
  Tool_50 = Tool.copy()
  Coil_44.subtract(Tool_50)
  Tool_51 = Tool.copy()
  Coil_45.subtract(Tool_51)
  Tool_52 = Tool.copy()
  Coil_46.subtract(Tool_52)
  Tool_53 = Tool.copy()
  Coil_47.subtract(Tool_53)
  Rotor.subtract(Tool)
motion:
  MotionSetup1: Band Move_Type=Rotate Coordinate_System=Global Axis=Z Is_Positive=true InitPos=0deg Angular_Velocity=741.966rpm Objects=Band
  Moving1: Moving Objects=[Shaft, Rotor, Bar, Bar_Separate1..Bar_Separate56, InnerRegion]
boundaries and excitations:
  VectorPotential1: Vector Potential Edges=OuterRegion.edge(at (0, 339.35, 0)) Value=0
  PhARe_0: Coil Objects=Coil_43 Conductor_number=4 Winding=PhaseA PolarityType=Negative
  PhA_0: Coil Objects=Coil_0 Conductor_number=4 Winding=PhaseA PolarityType=Positive
  PhA_1: Coil Objects=Coil_1 Conductor_number=4 Winding=PhaseA PolarityType=Positive
  PhARe_1: Coil Objects=Coil_6 Conductor_number=4 Winding=PhaseA PolarityType=Negative
  PhBRe_2: Coil Objects=Coil_47 Conductor_number=4 Winding=PhaseB PolarityType=Negative
  PhB_2: Coil Objects=Coil_4 Conductor_number=4 Winding=PhaseB PolarityType=Positive
  PhB_3: Coil Objects=Coil_5 Conductor_number=4 Winding=PhaseB PolarityType=Positive
  PhBRe_3: Coil Objects=Coil_10 Conductor_number=4 Winding=PhaseB PolarityType=Negative
  PhCRe_4: Coil Objects=Coil_3 Conductor_number=4 Winding=PhaseC PolarityType=Negative
  PhC_4: Coil Objects=Coil_8 Conductor_number=4 Winding=PhaseC PolarityType=Positive
  PhC_5: Coil Objects=Coil_9 Conductor_number=4 Winding=PhaseC PolarityType=Positive
  PhCRe_5: Coil Objects=Coil_14 Conductor_number=4 Winding=PhaseC PolarityType=Negative
  PhARe_6: Coil Objects=Coil_7 Conductor_number=4 Winding=PhaseA PolarityType=Negative
  PhA_6: Coil Objects=Coil_12 Conductor_number=4 Winding=PhaseA PolarityType=Positive
  PhA_7: Coil Objects=Coil_13 Conductor_number=4 Winding=PhaseA PolarityType=Positive
  PhARe_7: Coil Objects=Coil_18 Conductor_number=4 Winding=PhaseA PolarityType=Negative
  PhBRe_8: Coil Objects=Coil_11 Conductor_number=4 Winding=PhaseB PolarityType=Negative
  PhB_8: Coil Objects=Coil_16 Conductor_number=4 Winding=PhaseB PolarityType=Positive
  PhB_9: Coil Objects=Coil_17 Conductor_number=4 Winding=PhaseB PolarityType=Positive
  PhBRe_9: Coil Objects=Coil_22 Conductor_number=4 Winding=PhaseB PolarityType=Negative
  PhCRe_10: Coil Objects=Coil_15 Conductor_number=4 Winding=PhaseC PolarityType=Negative
  PhC_10: Coil Objects=Coil_20 Conductor_number=4 Winding=PhaseC PolarityType=Positive
  PhC_11: Coil Objects=Coil_21 Conductor_number=4 Winding=PhaseC PolarityType=Positive
  PhCRe_11: Coil Objects=Coil_26 Conductor_number=4 Winding=PhaseC PolarityType=Negative
  PhARe_12: Coil Objects=Coil_19 Conductor_number=4 Winding=PhaseA PolarityType=Negative
  PhA_12: Coil Objects=Coil_24 Conductor_number=4 Winding=PhaseA PolarityType=Positive
  PhA_13: Coil Objects=Coil_25 Conductor_number=4 Winding=PhaseA PolarityType=Positive
  PhARe_13: Coil Objects=Coil_30 Conductor_number=4 Winding=PhaseA PolarityType=Negative
  PhBRe_14: Coil Objects=Coil_23 Conductor_number=4 Winding=PhaseB PolarityType=Negative
  PhB_14: Coil Objects=Coil_28 Conductor_number=4 Winding=PhaseB PolarityType=Positive
  PhB_15: Coil Objects=Coil_29 Conductor_number=4 Winding=PhaseB PolarityType=Positive
  PhBRe_15: Coil Objects=Coil_34 Conductor_number=4 Winding=PhaseB PolarityType=Negative
  PhCRe_16: Coil Objects=Coil_27 Conductor_number=4 Winding=PhaseC PolarityType=Negative
  PhC_16: Coil Objects=Coil_32 Conductor_number=4 Winding=PhaseC PolarityType=Positive
  PhC_17: Coil Objects=Coil_33 Conductor_number=4 Winding=PhaseC PolarityType=Positive
  PhCRe_17: Coil Objects=Coil_38 Conductor_number=4 Winding=PhaseC PolarityType=Negative
  PhARe_18: Coil Objects=Coil_31 Conductor_number=4 Winding=PhaseA PolarityType=Negative
  PhA_18: Coil Objects=Coil_36 Conductor_number=4 Winding=PhaseA PolarityType=Positive
  PhA_19: Coil Objects=Coil_37 Conductor_number=4 Winding=PhaseA PolarityType=Positive
  PhARe_19: Coil Objects=Coil_42 Conductor_number=4 Winding=PhaseA PolarityType=Negative
  PhBRe_20: Coil Objects=Coil_35 Conductor_number=4 Winding=PhaseB PolarityType=Negative
  PhB_20: Coil Objects=Coil_40 Conductor_number=4 Winding=PhaseB PolarityType=Positive
  PhB_21: Coil Objects=Coil_41 Conductor_number=4 Winding=PhaseB PolarityType=Positive
  PhBRe_21: Coil Objects=Coil_46 Conductor_number=4 Winding=PhaseB PolarityType=Negative
  PhCRe_22: Coil Objects=Coil_39 Conductor_number=4 Winding=PhaseC PolarityType=Negative
  PhC_22: Coil Objects=Coil_44 Conductor_number=4 Winding=PhaseC PolarityType=Positive
  PhC_23: Coil Objects=Coil_45 Conductor_number=4 Winding=PhaseC PolarityType=Positive
  PhCRe_23: Coil Objects=Coil_2 Conductor_number=4 Winding=PhaseC PolarityType=Negative
  EndConnection1: End Connection Objects=[Bar, Bar_Separate1..Bar_Separate56] ResistanceValue=7.83497e-007ohm InductanceValue=4.10253e-008H
  PhaseA: Winding Group Type=Voltage IsSolid=false Current=0A Resistance=0.0105785ohm Inductance=4.47982e-005H Voltage="326.599 * sin(2*pi*50*time)" ParallelBranchesNum=1
  PhaseB: Winding Group Type=Voltage IsSolid=false Current=0A Resistance=0.0105785ohm Inductance=4.47982e-005H Voltage="326.599 * sin(2*pi*50*time-2*pi/3)" ParallelBranchesNum=1
  PhaseC: Winding Group Type=Voltage IsSolid=false Current=0A Resistance=0.0105785ohm Inductance=4.47982e-005H Voltage="326.599 * sin(2*pi*50*time-4*pi/3)" ParallelBranchesNum=1
  Y connection: PhaseA, PhaseB, PhaseC
parameters:
  cogg: Torque Coordinate_System=Global Is_Positive=true Objects=Rotor
mesh:
  Length_Coil: LengthBased RefineInside Objects=[Coil_0..Coil_47] MaxLength=7.75mm
  Length_Bar: LengthBased RefineInside Objects=[Bar, Bar_Separate1..Bar_Separate56] MaxLength=4mm
  SurfApprox_Bar: SurfApproxBased Objects=[Bar, Bar_Separate1..Bar_Separate56] CurvedSurfaceApproxChoice=ManualSettings SurfDev=0.2614mm NormalDev=15deg
  SurfApprox_Main: SurfApproxBased Objects=[Stator, Rotor, Band, OuterRegion, InnerRegion, Shaft] CurvedSurfaceApproxChoice=ManualSettings SurfDev=0.33935mm NormalDev=15deg
  Length_Main: LengthBased RefineInside Objects=[Stator, Rotor, Band, OuterRegion, InnerRegion, Shaft] MaxLength=15.59mm
  initial mesh: MeshMethod=AnsoftTAU
setups:
  Setup1: Transient NonlinearSolverResidual=0.0001 StopTime=0.6s TimeStep=0.0002s FastReachSteadyState FrequencyOfAddedVoltageSource=50Hz InitialTimeStep=0.002s MinTimeStep=0.001s MaxTimeStep=0.003s TimeStepErrTolerance=0.0001
field plots:
  Mesh1: MeshPlots over Rotor on Setup1 : Transient at Time=0.04s
reports:
  Torque: Moving1.Torque vs Time on Setup1 : Transient; markers m1 at 5.814e+08ns
  Currents: Current(PhaseA), Current(PhaseB), Current(PhaseC) vs Time on Setup1 : Transient
  Induced Voltages: InducedVoltage(PhaseA), InducedVoltage(PhaseB), InducedVoltage(PhaseC) vs Time on Setup1 : Transient
  Flux Linkages: FluxLinkage(PhaseA), FluxLinkage(PhaseB), FluxLinkage(PhaseC) vs Time on Setup1 : Transient
  Voltages: InputVoltage(PhaseA), InputVoltage(PhaseB), InputVoltage(PhaseC) vs Time on Setup1 : Transient
  Powers: InputVoltage(PhaseA)*Current(PhaseA) + InputVoltage(PhaseB)*Current(PhaseB) + InputVoltage(PhaseC)*Current(PhaseC), Moving1.Speed*Moving1.Torque vs Time on Setup1 : Transient
